
{
    # File auto-generated by Padrick 0.1.0.post0.dev37+gc5ae078
    name: "alsaqr_periph_padframe_periphs_config"
    clock_primary: "clk_i"
    reset_primary: "rst_ni"
    bus_interfaces: [
        { protocol: "reg_iface", direction: "device"}
    ]
    regwidth: 32,
    registers: [
        {skipto: "0x0"},


























































































































      {
          name: PAD_MX_CAN_0_CFG
          desc: '''
            Pad signal configuration.
          '''
          swaccess: "rw"
          fields: [
            {
                bits: "0"
                name: chip2pad
                desc: '''
                     The signal that connects to the pads TX driver
                '''
                swaccess: "rw"
                hwaccess: "hro"
                resval: "0"
            },
            {
                bits: "1"
                name: oen
                desc: '''
                     Output enable signal, active low
                '''
                swaccess: "rw"
                hwaccess: "hro"
                resval: "1"
            },
          ]
      }

       {
          name: PAD_MX_CAN_0_MUX_SEL
          desc: '''
              Pad signal port multiplex selection for pad pad_mx_can_0. The programmed value defines which port
              is connected to the pad.
          '''
          swaccess: "rw"
          hwaccess: "hro"
          resval: 0
          fields: [
              {
                  bits: "3:0"
                  enum: [
                      { value: "0", name: "register", desc: "Connects the Pad to the internal configuration register."}
                      { value: "1", name: "port_CAN2_CAN_can1_rx", desc: "Connect port can1_rx from port group CAN2_CAN to this pad." }
                      { value: "2", name: "port_CAN2_CAN_can1_tx", desc: "Connect port can1_tx from port group CAN2_CAN to this pad." }
                      { value: "3", name: "port_CAN2_CAN_can2_rx", desc: "Connect port can2_rx from port group CAN2_CAN to this pad." }
                      { value: "4", name: "port_CAN2_CAN_can2_tx", desc: "Connect port can2_tx from port group CAN2_CAN to this pad." }
                      { value: "5", name: "port_spi7_spi_cs", desc: "Connect port spi_cs from port group spi7 to this pad." }
                      { value: "6", name: "port_spi7_spi_miso", desc: "Connect port spi_miso from port group spi7 to this pad." }
                      { value: "7", name: "port_spi7_spi_mosi", desc: "Connect port spi_mosi from port group spi7 to this pad." }
                      { value: "8", name: "port_spi7_spi_sck", desc: "Connect port spi_sck from port group spi7 to this pad." }
                  ]
              }
          ]
      }

      {
          name: PAD_MX_CAN_1_CFG
          desc: '''
            Pad signal configuration.
          '''
          swaccess: "rw"
          fields: [
            {
                bits: "0"
                name: chip2pad
                desc: '''
                     The signal that connects to the pads TX driver
                '''
                swaccess: "rw"
                hwaccess: "hro"
                resval: "0"
            },
            {
                bits: "1"
                name: oen
                desc: '''
                     Output enable signal, active low
                '''
                swaccess: "rw"
                hwaccess: "hro"
                resval: "1"
            },
          ]
      }

       {
          name: PAD_MX_CAN_1_MUX_SEL
          desc: '''
              Pad signal port multiplex selection for pad pad_mx_can_1. The programmed value defines which port
              is connected to the pad.
          '''
          swaccess: "rw"
          hwaccess: "hro"
          resval: 0
          fields: [
              {
                  bits: "3:0"
                  enum: [
                      { value: "0", name: "register", desc: "Connects the Pad to the internal configuration register."}
                      { value: "1", name: "port_CAN2_CAN_can1_rx", desc: "Connect port can1_rx from port group CAN2_CAN to this pad." }
                      { value: "2", name: "port_CAN2_CAN_can1_tx", desc: "Connect port can1_tx from port group CAN2_CAN to this pad." }
                      { value: "3", name: "port_CAN2_CAN_can2_rx", desc: "Connect port can2_rx from port group CAN2_CAN to this pad." }
                      { value: "4", name: "port_CAN2_CAN_can2_tx", desc: "Connect port can2_tx from port group CAN2_CAN to this pad." }
                      { value: "5", name: "port_spi7_spi_cs", desc: "Connect port spi_cs from port group spi7 to this pad." }
                      { value: "6", name: "port_spi7_spi_miso", desc: "Connect port spi_miso from port group spi7 to this pad." }
                      { value: "7", name: "port_spi7_spi_mosi", desc: "Connect port spi_mosi from port group spi7 to this pad." }
                      { value: "8", name: "port_spi7_spi_sck", desc: "Connect port spi_sck from port group spi7 to this pad." }
                  ]
              }
          ]
      }

      {
          name: PAD_MX_CAN_2_CFG
          desc: '''
            Pad signal configuration.
          '''
          swaccess: "rw"
          fields: [
            {
                bits: "0"
                name: chip2pad
                desc: '''
                     The signal that connects to the pads TX driver
                '''
                swaccess: "rw"
                hwaccess: "hro"
                resval: "0"
            },
            {
                bits: "1"
                name: oen
                desc: '''
                     Output enable signal, active low
                '''
                swaccess: "rw"
                hwaccess: "hro"
                resval: "1"
            },
          ]
      }

       {
          name: PAD_MX_CAN_2_MUX_SEL
          desc: '''
              Pad signal port multiplex selection for pad pad_mx_can_2. The programmed value defines which port
              is connected to the pad.
          '''
          swaccess: "rw"
          hwaccess: "hro"
          resval: 0
          fields: [
              {
                  bits: "3:0"
                  enum: [
                      { value: "0", name: "register", desc: "Connects the Pad to the internal configuration register."}
                      { value: "1", name: "port_CAN2_CAN_can1_rx", desc: "Connect port can1_rx from port group CAN2_CAN to this pad." }
                      { value: "2", name: "port_CAN2_CAN_can1_tx", desc: "Connect port can1_tx from port group CAN2_CAN to this pad." }
                      { value: "3", name: "port_CAN2_CAN_can2_rx", desc: "Connect port can2_rx from port group CAN2_CAN to this pad." }
                      { value: "4", name: "port_CAN2_CAN_can2_tx", desc: "Connect port can2_tx from port group CAN2_CAN to this pad." }
                      { value: "5", name: "port_spi7_spi_cs", desc: "Connect port spi_cs from port group spi7 to this pad." }
                      { value: "6", name: "port_spi7_spi_miso", desc: "Connect port spi_miso from port group spi7 to this pad." }
                      { value: "7", name: "port_spi7_spi_mosi", desc: "Connect port spi_mosi from port group spi7 to this pad." }
                      { value: "8", name: "port_spi7_spi_sck", desc: "Connect port spi_sck from port group spi7 to this pad." }
                  ]
              }
          ]
      }

      {
          name: PAD_MX_CAN_3_CFG
          desc: '''
            Pad signal configuration.
          '''
          swaccess: "rw"
          fields: [
            {
                bits: "0"
                name: chip2pad
                desc: '''
                     The signal that connects to the pads TX driver
                '''
                swaccess: "rw"
                hwaccess: "hro"
                resval: "0"
            },
            {
                bits: "1"
                name: oen
                desc: '''
                     Output enable signal, active low
                '''
                swaccess: "rw"
                hwaccess: "hro"
                resval: "1"
            },
          ]
      }

       {
          name: PAD_MX_CAN_3_MUX_SEL
          desc: '''
              Pad signal port multiplex selection for pad pad_mx_can_3. The programmed value defines which port
              is connected to the pad.
          '''
          swaccess: "rw"
          hwaccess: "hro"
          resval: 0
          fields: [
              {
                  bits: "3:0"
                  enum: [
                      { value: "0", name: "register", desc: "Connects the Pad to the internal configuration register."}
                      { value: "1", name: "port_CAN2_CAN_can1_rx", desc: "Connect port can1_rx from port group CAN2_CAN to this pad." }
                      { value: "2", name: "port_CAN2_CAN_can1_tx", desc: "Connect port can1_tx from port group CAN2_CAN to this pad." }
                      { value: "3", name: "port_CAN2_CAN_can2_rx", desc: "Connect port can2_rx from port group CAN2_CAN to this pad." }
                      { value: "4", name: "port_CAN2_CAN_can2_tx", desc: "Connect port can2_tx from port group CAN2_CAN to this pad." }
                      { value: "5", name: "port_spi7_spi_cs", desc: "Connect port spi_cs from port group spi7 to this pad." }
                      { value: "6", name: "port_spi7_spi_miso", desc: "Connect port spi_miso from port group spi7 to this pad." }
                      { value: "7", name: "port_spi7_spi_mosi", desc: "Connect port spi_mosi from port group spi7 to this pad." }
                      { value: "8", name: "port_spi7_spi_sck", desc: "Connect port spi_sck from port group spi7 to this pad." }
                  ]
              }
          ]
      }

      {
          name: PAD_MX_CAM0_0_CFG
          desc: '''
            Pad signal configuration.
          '''
          swaccess: "rw"
          fields: [
            {
                bits: "0"
                name: chip2pad
                desc: '''
                     The signal that connects to the pads TX driver
                '''
                swaccess: "rw"
                hwaccess: "hro"
                resval: "0"
            },
            {
                bits: "1"
                name: oen
                desc: '''
                     Output enable signal, active low
                '''
                swaccess: "rw"
                hwaccess: "hro"
                resval: "1"
            },
          ]
      }

       {
          name: PAD_MX_CAM0_0_MUX_SEL
          desc: '''
              Pad signal port multiplex selection for pad pad_mx_cam0_0. The programmed value defines which port
              is connected to the pad.
          '''
          swaccess: "rw"
          hwaccess: "hro"
          resval: 0
          fields: [
              {
                  bits: "4:0"
                  enum: [
                      { value: "0", name: "register", desc: "Connects the Pad to the internal configuration register."}
                      { value: "1", name: "port_IMU2_DRDY_gpio57", desc: "Connect port gpio57 from port group IMU2_DRDY to this pad." }
                      { value: "2", name: "port_cam0_cam_data0_i", desc: "Connect port cam_data0_i from port group cam0 to this pad." }
                      { value: "3", name: "port_cam0_cam_data1_i", desc: "Connect port cam_data1_i from port group cam0 to this pad." }
                      { value: "4", name: "port_cam0_cam_data2_i", desc: "Connect port cam_data2_i from port group cam0 to this pad." }
                      { value: "5", name: "port_cam0_cam_data3_i", desc: "Connect port cam_data3_i from port group cam0 to this pad." }
                      { value: "6", name: "port_cam0_cam_data4_i", desc: "Connect port cam_data4_i from port group cam0 to this pad." }
                      { value: "7", name: "port_cam0_cam_data5_i", desc: "Connect port cam_data5_i from port group cam0 to this pad." }
                      { value: "8", name: "port_cam0_cam_data6_i", desc: "Connect port cam_data6_i from port group cam0 to this pad." }
                      { value: "9", name: "port_cam0_cam_data7_i", desc: "Connect port cam_data7_i from port group cam0 to this pad." }
                      { value: "10", name: "port_cam0_cam_hsync", desc: "Connect port cam_hsync from port group cam0 to this pad." }
                      { value: "11", name: "port_cam0_cam_pclk", desc: "Connect port cam_pclk from port group cam0 to this pad." }
                      { value: "12", name: "port_cam0_cam_vsync", desc: "Connect port cam_vsync from port group cam0 to this pad." }
                      { value: "13", name: "port_i2c3_i2c_scl", desc: "Connect port i2c_scl from port group i2c3 to this pad." }
                      { value: "14", name: "port_i2c3_i2c_sda", desc: "Connect port i2c_sda from port group i2c3 to this pad." }
                      { value: "15", name: "port_spi8_spi_cs", desc: "Connect port spi_cs from port group spi8 to this pad." }
                      { value: "16", name: "port_spi8_spi_miso", desc: "Connect port spi_miso from port group spi8 to this pad." }
                      { value: "17", name: "port_spi8_spi_mosi", desc: "Connect port spi_mosi from port group spi8 to this pad." }
                      { value: "18", name: "port_spi8_spi_sck", desc: "Connect port spi_sck from port group spi8 to this pad." }
                      { value: "19", name: "port_spi9_spi_cs", desc: "Connect port spi_cs from port group spi9 to this pad." }
                      { value: "20", name: "port_spi9_spi_miso", desc: "Connect port spi_miso from port group spi9 to this pad." }
                      { value: "21", name: "port_spi9_spi_mosi", desc: "Connect port spi_mosi from port group spi9 to this pad." }
                      { value: "22", name: "port_spi9_spi_sck", desc: "Connect port spi_sck from port group spi9 to this pad." }
                  ]
              }
          ]
      }

      {
          name: PAD_MX_CAM0_1_CFG
          desc: '''
            Pad signal configuration.
          '''
          swaccess: "rw"
          fields: [
            {
                bits: "0"
                name: chip2pad
                desc: '''
                     The signal that connects to the pads TX driver
                '''
                swaccess: "rw"
                hwaccess: "hro"
                resval: "0"
            },
            {
                bits: "1"
                name: oen
                desc: '''
                     Output enable signal, active low
                '''
                swaccess: "rw"
                hwaccess: "hro"
                resval: "1"
            },
          ]
      }

       {
          name: PAD_MX_CAM0_1_MUX_SEL
          desc: '''
              Pad signal port multiplex selection for pad pad_mx_cam0_1. The programmed value defines which port
              is connected to the pad.
          '''
          swaccess: "rw"
          hwaccess: "hro"
          resval: 0
          fields: [
              {
                  bits: "4:0"
                  enum: [
                      { value: "0", name: "register", desc: "Connects the Pad to the internal configuration register."}
                      { value: "1", name: "port_IMU2_DRDY_gpio57", desc: "Connect port gpio57 from port group IMU2_DRDY to this pad." }
                      { value: "2", name: "port_cam0_cam_data0_i", desc: "Connect port cam_data0_i from port group cam0 to this pad." }
                      { value: "3", name: "port_cam0_cam_data1_i", desc: "Connect port cam_data1_i from port group cam0 to this pad." }
                      { value: "4", name: "port_cam0_cam_data2_i", desc: "Connect port cam_data2_i from port group cam0 to this pad." }
                      { value: "5", name: "port_cam0_cam_data3_i", desc: "Connect port cam_data3_i from port group cam0 to this pad." }
                      { value: "6", name: "port_cam0_cam_data4_i", desc: "Connect port cam_data4_i from port group cam0 to this pad." }
                      { value: "7", name: "port_cam0_cam_data5_i", desc: "Connect port cam_data5_i from port group cam0 to this pad." }
                      { value: "8", name: "port_cam0_cam_data6_i", desc: "Connect port cam_data6_i from port group cam0 to this pad." }
                      { value: "9", name: "port_cam0_cam_data7_i", desc: "Connect port cam_data7_i from port group cam0 to this pad." }
                      { value: "10", name: "port_cam0_cam_hsync", desc: "Connect port cam_hsync from port group cam0 to this pad." }
                      { value: "11", name: "port_cam0_cam_pclk", desc: "Connect port cam_pclk from port group cam0 to this pad." }
                      { value: "12", name: "port_cam0_cam_vsync", desc: "Connect port cam_vsync from port group cam0 to this pad." }
                      { value: "13", name: "port_i2c3_i2c_scl", desc: "Connect port i2c_scl from port group i2c3 to this pad." }
                      { value: "14", name: "port_i2c3_i2c_sda", desc: "Connect port i2c_sda from port group i2c3 to this pad." }
                      { value: "15", name: "port_spi8_spi_cs", desc: "Connect port spi_cs from port group spi8 to this pad." }
                      { value: "16", name: "port_spi8_spi_miso", desc: "Connect port spi_miso from port group spi8 to this pad." }
                      { value: "17", name: "port_spi8_spi_mosi", desc: "Connect port spi_mosi from port group spi8 to this pad." }
                      { value: "18", name: "port_spi8_spi_sck", desc: "Connect port spi_sck from port group spi8 to this pad." }
                      { value: "19", name: "port_spi9_spi_cs", desc: "Connect port spi_cs from port group spi9 to this pad." }
                      { value: "20", name: "port_spi9_spi_miso", desc: "Connect port spi_miso from port group spi9 to this pad." }
                      { value: "21", name: "port_spi9_spi_mosi", desc: "Connect port spi_mosi from port group spi9 to this pad." }
                      { value: "22", name: "port_spi9_spi_sck", desc: "Connect port spi_sck from port group spi9 to this pad." }
                  ]
              }
          ]
      }

      {
          name: PAD_MX_CAM0_2_CFG
          desc: '''
            Pad signal configuration.
          '''
          swaccess: "rw"
          fields: [
            {
                bits: "0"
                name: chip2pad
                desc: '''
                     The signal that connects to the pads TX driver
                '''
                swaccess: "rw"
                hwaccess: "hro"
                resval: "0"
            },
            {
                bits: "1"
                name: oen
                desc: '''
                     Output enable signal, active low
                '''
                swaccess: "rw"
                hwaccess: "hro"
                resval: "1"
            },
          ]
      }

       {
          name: PAD_MX_CAM0_2_MUX_SEL
          desc: '''
              Pad signal port multiplex selection for pad pad_mx_cam0_2. The programmed value defines which port
              is connected to the pad.
          '''
          swaccess: "rw"
          hwaccess: "hro"
          resval: 0
          fields: [
              {
                  bits: "4:0"
                  enum: [
                      { value: "0", name: "register", desc: "Connects the Pad to the internal configuration register."}
                      { value: "1", name: "port_IMU2_DRDY_gpio57", desc: "Connect port gpio57 from port group IMU2_DRDY to this pad." }
                      { value: "2", name: "port_cam0_cam_data0_i", desc: "Connect port cam_data0_i from port group cam0 to this pad." }
                      { value: "3", name: "port_cam0_cam_data1_i", desc: "Connect port cam_data1_i from port group cam0 to this pad." }
                      { value: "4", name: "port_cam0_cam_data2_i", desc: "Connect port cam_data2_i from port group cam0 to this pad." }
                      { value: "5", name: "port_cam0_cam_data3_i", desc: "Connect port cam_data3_i from port group cam0 to this pad." }
                      { value: "6", name: "port_cam0_cam_data4_i", desc: "Connect port cam_data4_i from port group cam0 to this pad." }
                      { value: "7", name: "port_cam0_cam_data5_i", desc: "Connect port cam_data5_i from port group cam0 to this pad." }
                      { value: "8", name: "port_cam0_cam_data6_i", desc: "Connect port cam_data6_i from port group cam0 to this pad." }
                      { value: "9", name: "port_cam0_cam_data7_i", desc: "Connect port cam_data7_i from port group cam0 to this pad." }
                      { value: "10", name: "port_cam0_cam_hsync", desc: "Connect port cam_hsync from port group cam0 to this pad." }
                      { value: "11", name: "port_cam0_cam_pclk", desc: "Connect port cam_pclk from port group cam0 to this pad." }
                      { value: "12", name: "port_cam0_cam_vsync", desc: "Connect port cam_vsync from port group cam0 to this pad." }
                      { value: "13", name: "port_i2c3_i2c_scl", desc: "Connect port i2c_scl from port group i2c3 to this pad." }
                      { value: "14", name: "port_i2c3_i2c_sda", desc: "Connect port i2c_sda from port group i2c3 to this pad." }
                      { value: "15", name: "port_spi8_spi_cs", desc: "Connect port spi_cs from port group spi8 to this pad." }
                      { value: "16", name: "port_spi8_spi_miso", desc: "Connect port spi_miso from port group spi8 to this pad." }
                      { value: "17", name: "port_spi8_spi_mosi", desc: "Connect port spi_mosi from port group spi8 to this pad." }
                      { value: "18", name: "port_spi8_spi_sck", desc: "Connect port spi_sck from port group spi8 to this pad." }
                      { value: "19", name: "port_spi9_spi_cs", desc: "Connect port spi_cs from port group spi9 to this pad." }
                      { value: "20", name: "port_spi9_spi_miso", desc: "Connect port spi_miso from port group spi9 to this pad." }
                      { value: "21", name: "port_spi9_spi_mosi", desc: "Connect port spi_mosi from port group spi9 to this pad." }
                      { value: "22", name: "port_spi9_spi_sck", desc: "Connect port spi_sck from port group spi9 to this pad." }
                  ]
              }
          ]
      }

      {
          name: PAD_MX_CAM0_3_CFG
          desc: '''
            Pad signal configuration.
          '''
          swaccess: "rw"
          fields: [
            {
                bits: "0"
                name: chip2pad
                desc: '''
                     The signal that connects to the pads TX driver
                '''
                swaccess: "rw"
                hwaccess: "hro"
                resval: "0"
            },
            {
                bits: "1"
                name: oen
                desc: '''
                     Output enable signal, active low
                '''
                swaccess: "rw"
                hwaccess: "hro"
                resval: "1"
            },
          ]
      }

       {
          name: PAD_MX_CAM0_3_MUX_SEL
          desc: '''
              Pad signal port multiplex selection for pad pad_mx_cam0_3. The programmed value defines which port
              is connected to the pad.
          '''
          swaccess: "rw"
          hwaccess: "hro"
          resval: 0
          fields: [
              {
                  bits: "4:0"
                  enum: [
                      { value: "0", name: "register", desc: "Connects the Pad to the internal configuration register."}
                      { value: "1", name: "port_IMU2_DRDY_gpio57", desc: "Connect port gpio57 from port group IMU2_DRDY to this pad." }
                      { value: "2", name: "port_cam0_cam_data0_i", desc: "Connect port cam_data0_i from port group cam0 to this pad." }
                      { value: "3", name: "port_cam0_cam_data1_i", desc: "Connect port cam_data1_i from port group cam0 to this pad." }
                      { value: "4", name: "port_cam0_cam_data2_i", desc: "Connect port cam_data2_i from port group cam0 to this pad." }
                      { value: "5", name: "port_cam0_cam_data3_i", desc: "Connect port cam_data3_i from port group cam0 to this pad." }
                      { value: "6", name: "port_cam0_cam_data4_i", desc: "Connect port cam_data4_i from port group cam0 to this pad." }
                      { value: "7", name: "port_cam0_cam_data5_i", desc: "Connect port cam_data5_i from port group cam0 to this pad." }
                      { value: "8", name: "port_cam0_cam_data6_i", desc: "Connect port cam_data6_i from port group cam0 to this pad." }
                      { value: "9", name: "port_cam0_cam_data7_i", desc: "Connect port cam_data7_i from port group cam0 to this pad." }
                      { value: "10", name: "port_cam0_cam_hsync", desc: "Connect port cam_hsync from port group cam0 to this pad." }
                      { value: "11", name: "port_cam0_cam_pclk", desc: "Connect port cam_pclk from port group cam0 to this pad." }
                      { value: "12", name: "port_cam0_cam_vsync", desc: "Connect port cam_vsync from port group cam0 to this pad." }
                      { value: "13", name: "port_i2c3_i2c_scl", desc: "Connect port i2c_scl from port group i2c3 to this pad." }
                      { value: "14", name: "port_i2c3_i2c_sda", desc: "Connect port i2c_sda from port group i2c3 to this pad." }
                      { value: "15", name: "port_spi8_spi_cs", desc: "Connect port spi_cs from port group spi8 to this pad." }
                      { value: "16", name: "port_spi8_spi_miso", desc: "Connect port spi_miso from port group spi8 to this pad." }
                      { value: "17", name: "port_spi8_spi_mosi", desc: "Connect port spi_mosi from port group spi8 to this pad." }
                      { value: "18", name: "port_spi8_spi_sck", desc: "Connect port spi_sck from port group spi8 to this pad." }
                      { value: "19", name: "port_spi9_spi_cs", desc: "Connect port spi_cs from port group spi9 to this pad." }
                      { value: "20", name: "port_spi9_spi_miso", desc: "Connect port spi_miso from port group spi9 to this pad." }
                      { value: "21", name: "port_spi9_spi_mosi", desc: "Connect port spi_mosi from port group spi9 to this pad." }
                      { value: "22", name: "port_spi9_spi_sck", desc: "Connect port spi_sck from port group spi9 to this pad." }
                  ]
              }
          ]
      }

      {
          name: PAD_MX_CAM0_4_CFG
          desc: '''
            Pad signal configuration.
          '''
          swaccess: "rw"
          fields: [
            {
                bits: "0"
                name: chip2pad
                desc: '''
                     The signal that connects to the pads TX driver
                '''
                swaccess: "rw"
                hwaccess: "hro"
                resval: "0"
            },
            {
                bits: "1"
                name: oen
                desc: '''
                     Output enable signal, active low
                '''
                swaccess: "rw"
                hwaccess: "hro"
                resval: "1"
            },
          ]
      }

       {
          name: PAD_MX_CAM0_4_MUX_SEL
          desc: '''
              Pad signal port multiplex selection for pad pad_mx_cam0_4. The programmed value defines which port
              is connected to the pad.
          '''
          swaccess: "rw"
          hwaccess: "hro"
          resval: 0
          fields: [
              {
                  bits: "4:0"
                  enum: [
                      { value: "0", name: "register", desc: "Connects the Pad to the internal configuration register."}
                      { value: "1", name: "port_IMU2_DRDY_gpio57", desc: "Connect port gpio57 from port group IMU2_DRDY to this pad." }
                      { value: "2", name: "port_cam0_cam_data0_i", desc: "Connect port cam_data0_i from port group cam0 to this pad." }
                      { value: "3", name: "port_cam0_cam_data1_i", desc: "Connect port cam_data1_i from port group cam0 to this pad." }
                      { value: "4", name: "port_cam0_cam_data2_i", desc: "Connect port cam_data2_i from port group cam0 to this pad." }
                      { value: "5", name: "port_cam0_cam_data3_i", desc: "Connect port cam_data3_i from port group cam0 to this pad." }
                      { value: "6", name: "port_cam0_cam_data4_i", desc: "Connect port cam_data4_i from port group cam0 to this pad." }
                      { value: "7", name: "port_cam0_cam_data5_i", desc: "Connect port cam_data5_i from port group cam0 to this pad." }
                      { value: "8", name: "port_cam0_cam_data6_i", desc: "Connect port cam_data6_i from port group cam0 to this pad." }
                      { value: "9", name: "port_cam0_cam_data7_i", desc: "Connect port cam_data7_i from port group cam0 to this pad." }
                      { value: "10", name: "port_cam0_cam_hsync", desc: "Connect port cam_hsync from port group cam0 to this pad." }
                      { value: "11", name: "port_cam0_cam_pclk", desc: "Connect port cam_pclk from port group cam0 to this pad." }
                      { value: "12", name: "port_cam0_cam_vsync", desc: "Connect port cam_vsync from port group cam0 to this pad." }
                      { value: "13", name: "port_i2c3_i2c_scl", desc: "Connect port i2c_scl from port group i2c3 to this pad." }
                      { value: "14", name: "port_i2c3_i2c_sda", desc: "Connect port i2c_sda from port group i2c3 to this pad." }
                      { value: "15", name: "port_spi8_spi_cs", desc: "Connect port spi_cs from port group spi8 to this pad." }
                      { value: "16", name: "port_spi8_spi_miso", desc: "Connect port spi_miso from port group spi8 to this pad." }
                      { value: "17", name: "port_spi8_spi_mosi", desc: "Connect port spi_mosi from port group spi8 to this pad." }
                      { value: "18", name: "port_spi8_spi_sck", desc: "Connect port spi_sck from port group spi8 to this pad." }
                      { value: "19", name: "port_spi9_spi_cs", desc: "Connect port spi_cs from port group spi9 to this pad." }
                      { value: "20", name: "port_spi9_spi_miso", desc: "Connect port spi_miso from port group spi9 to this pad." }
                      { value: "21", name: "port_spi9_spi_mosi", desc: "Connect port spi_mosi from port group spi9 to this pad." }
                      { value: "22", name: "port_spi9_spi_sck", desc: "Connect port spi_sck from port group spi9 to this pad." }
                  ]
              }
          ]
      }

      {
          name: PAD_MX_CAM0_5_CFG
          desc: '''
            Pad signal configuration.
          '''
          swaccess: "rw"
          fields: [
            {
                bits: "0"
                name: chip2pad
                desc: '''
                     The signal that connects to the pads TX driver
                '''
                swaccess: "rw"
                hwaccess: "hro"
                resval: "0"
            },
            {
                bits: "1"
                name: oen
                desc: '''
                     Output enable signal, active low
                '''
                swaccess: "rw"
                hwaccess: "hro"
                resval: "1"
            },
          ]
      }

       {
          name: PAD_MX_CAM0_5_MUX_SEL
          desc: '''
              Pad signal port multiplex selection for pad pad_mx_cam0_5. The programmed value defines which port
              is connected to the pad.
          '''
          swaccess: "rw"
          hwaccess: "hro"
          resval: 0
          fields: [
              {
                  bits: "4:0"
                  enum: [
                      { value: "0", name: "register", desc: "Connects the Pad to the internal configuration register."}
                      { value: "1", name: "port_IMU2_DRDY_gpio57", desc: "Connect port gpio57 from port group IMU2_DRDY to this pad." }
                      { value: "2", name: "port_cam0_cam_data0_i", desc: "Connect port cam_data0_i from port group cam0 to this pad." }
                      { value: "3", name: "port_cam0_cam_data1_i", desc: "Connect port cam_data1_i from port group cam0 to this pad." }
                      { value: "4", name: "port_cam0_cam_data2_i", desc: "Connect port cam_data2_i from port group cam0 to this pad." }
                      { value: "5", name: "port_cam0_cam_data3_i", desc: "Connect port cam_data3_i from port group cam0 to this pad." }
                      { value: "6", name: "port_cam0_cam_data4_i", desc: "Connect port cam_data4_i from port group cam0 to this pad." }
                      { value: "7", name: "port_cam0_cam_data5_i", desc: "Connect port cam_data5_i from port group cam0 to this pad." }
                      { value: "8", name: "port_cam0_cam_data6_i", desc: "Connect port cam_data6_i from port group cam0 to this pad." }
                      { value: "9", name: "port_cam0_cam_data7_i", desc: "Connect port cam_data7_i from port group cam0 to this pad." }
                      { value: "10", name: "port_cam0_cam_hsync", desc: "Connect port cam_hsync from port group cam0 to this pad." }
                      { value: "11", name: "port_cam0_cam_pclk", desc: "Connect port cam_pclk from port group cam0 to this pad." }
                      { value: "12", name: "port_cam0_cam_vsync", desc: "Connect port cam_vsync from port group cam0 to this pad." }
                      { value: "13", name: "port_i2c3_i2c_scl", desc: "Connect port i2c_scl from port group i2c3 to this pad." }
                      { value: "14", name: "port_i2c3_i2c_sda", desc: "Connect port i2c_sda from port group i2c3 to this pad." }
                      { value: "15", name: "port_spi8_spi_cs", desc: "Connect port spi_cs from port group spi8 to this pad." }
                      { value: "16", name: "port_spi8_spi_miso", desc: "Connect port spi_miso from port group spi8 to this pad." }
                      { value: "17", name: "port_spi8_spi_mosi", desc: "Connect port spi_mosi from port group spi8 to this pad." }
                      { value: "18", name: "port_spi8_spi_sck", desc: "Connect port spi_sck from port group spi8 to this pad." }
                      { value: "19", name: "port_spi9_spi_cs", desc: "Connect port spi_cs from port group spi9 to this pad." }
                      { value: "20", name: "port_spi9_spi_miso", desc: "Connect port spi_miso from port group spi9 to this pad." }
                      { value: "21", name: "port_spi9_spi_mosi", desc: "Connect port spi_mosi from port group spi9 to this pad." }
                      { value: "22", name: "port_spi9_spi_sck", desc: "Connect port spi_sck from port group spi9 to this pad." }
                  ]
              }
          ]
      }

      {
          name: PAD_MX_CAM0_6_CFG
          desc: '''
            Pad signal configuration.
          '''
          swaccess: "rw"
          fields: [
            {
                bits: "0"
                name: chip2pad
                desc: '''
                     The signal that connects to the pads TX driver
                '''
                swaccess: "rw"
                hwaccess: "hro"
                resval: "0"
            },
            {
                bits: "1"
                name: oen
                desc: '''
                     Output enable signal, active low
                '''
                swaccess: "rw"
                hwaccess: "hro"
                resval: "1"
            },
          ]
      }

       {
          name: PAD_MX_CAM0_6_MUX_SEL
          desc: '''
              Pad signal port multiplex selection for pad pad_mx_cam0_6. The programmed value defines which port
              is connected to the pad.
          '''
          swaccess: "rw"
          hwaccess: "hro"
          resval: 0
          fields: [
              {
                  bits: "4:0"
                  enum: [
                      { value: "0", name: "register", desc: "Connects the Pad to the internal configuration register."}
                      { value: "1", name: "port_IMU2_DRDY_gpio57", desc: "Connect port gpio57 from port group IMU2_DRDY to this pad." }
                      { value: "2", name: "port_cam0_cam_data0_i", desc: "Connect port cam_data0_i from port group cam0 to this pad." }
                      { value: "3", name: "port_cam0_cam_data1_i", desc: "Connect port cam_data1_i from port group cam0 to this pad." }
                      { value: "4", name: "port_cam0_cam_data2_i", desc: "Connect port cam_data2_i from port group cam0 to this pad." }
                      { value: "5", name: "port_cam0_cam_data3_i", desc: "Connect port cam_data3_i from port group cam0 to this pad." }
                      { value: "6", name: "port_cam0_cam_data4_i", desc: "Connect port cam_data4_i from port group cam0 to this pad." }
                      { value: "7", name: "port_cam0_cam_data5_i", desc: "Connect port cam_data5_i from port group cam0 to this pad." }
                      { value: "8", name: "port_cam0_cam_data6_i", desc: "Connect port cam_data6_i from port group cam0 to this pad." }
                      { value: "9", name: "port_cam0_cam_data7_i", desc: "Connect port cam_data7_i from port group cam0 to this pad." }
                      { value: "10", name: "port_cam0_cam_hsync", desc: "Connect port cam_hsync from port group cam0 to this pad." }
                      { value: "11", name: "port_cam0_cam_pclk", desc: "Connect port cam_pclk from port group cam0 to this pad." }
                      { value: "12", name: "port_cam0_cam_vsync", desc: "Connect port cam_vsync from port group cam0 to this pad." }
                      { value: "13", name: "port_i2c3_i2c_scl", desc: "Connect port i2c_scl from port group i2c3 to this pad." }
                      { value: "14", name: "port_i2c3_i2c_sda", desc: "Connect port i2c_sda from port group i2c3 to this pad." }
                      { value: "15", name: "port_spi8_spi_cs", desc: "Connect port spi_cs from port group spi8 to this pad." }
                      { value: "16", name: "port_spi8_spi_miso", desc: "Connect port spi_miso from port group spi8 to this pad." }
                      { value: "17", name: "port_spi8_spi_mosi", desc: "Connect port spi_mosi from port group spi8 to this pad." }
                      { value: "18", name: "port_spi8_spi_sck", desc: "Connect port spi_sck from port group spi8 to this pad." }
                      { value: "19", name: "port_spi9_spi_cs", desc: "Connect port spi_cs from port group spi9 to this pad." }
                      { value: "20", name: "port_spi9_spi_miso", desc: "Connect port spi_miso from port group spi9 to this pad." }
                      { value: "21", name: "port_spi9_spi_mosi", desc: "Connect port spi_mosi from port group spi9 to this pad." }
                      { value: "22", name: "port_spi9_spi_sck", desc: "Connect port spi_sck from port group spi9 to this pad." }
                  ]
              }
          ]
      }

      {
          name: PAD_MX_CAM0_7_CFG
          desc: '''
            Pad signal configuration.
          '''
          swaccess: "rw"
          fields: [
            {
                bits: "0"
                name: chip2pad
                desc: '''
                     The signal that connects to the pads TX driver
                '''
                swaccess: "rw"
                hwaccess: "hro"
                resval: "0"
            },
            {
                bits: "1"
                name: oen
                desc: '''
                     Output enable signal, active low
                '''
                swaccess: "rw"
                hwaccess: "hro"
                resval: "1"
            },
          ]
      }

       {
          name: PAD_MX_CAM0_7_MUX_SEL
          desc: '''
              Pad signal port multiplex selection for pad pad_mx_cam0_7. The programmed value defines which port
              is connected to the pad.
          '''
          swaccess: "rw"
          hwaccess: "hro"
          resval: 0
          fields: [
              {
                  bits: "4:0"
                  enum: [
                      { value: "0", name: "register", desc: "Connects the Pad to the internal configuration register."}
                      { value: "1", name: "port_IMU2_DRDY_gpio57", desc: "Connect port gpio57 from port group IMU2_DRDY to this pad." }
                      { value: "2", name: "port_cam0_cam_data0_i", desc: "Connect port cam_data0_i from port group cam0 to this pad." }
                      { value: "3", name: "port_cam0_cam_data1_i", desc: "Connect port cam_data1_i from port group cam0 to this pad." }
                      { value: "4", name: "port_cam0_cam_data2_i", desc: "Connect port cam_data2_i from port group cam0 to this pad." }
                      { value: "5", name: "port_cam0_cam_data3_i", desc: "Connect port cam_data3_i from port group cam0 to this pad." }
                      { value: "6", name: "port_cam0_cam_data4_i", desc: "Connect port cam_data4_i from port group cam0 to this pad." }
                      { value: "7", name: "port_cam0_cam_data5_i", desc: "Connect port cam_data5_i from port group cam0 to this pad." }
                      { value: "8", name: "port_cam0_cam_data6_i", desc: "Connect port cam_data6_i from port group cam0 to this pad." }
                      { value: "9", name: "port_cam0_cam_data7_i", desc: "Connect port cam_data7_i from port group cam0 to this pad." }
                      { value: "10", name: "port_cam0_cam_hsync", desc: "Connect port cam_hsync from port group cam0 to this pad." }
                      { value: "11", name: "port_cam0_cam_pclk", desc: "Connect port cam_pclk from port group cam0 to this pad." }
                      { value: "12", name: "port_cam0_cam_vsync", desc: "Connect port cam_vsync from port group cam0 to this pad." }
                      { value: "13", name: "port_i2c3_i2c_scl", desc: "Connect port i2c_scl from port group i2c3 to this pad." }
                      { value: "14", name: "port_i2c3_i2c_sda", desc: "Connect port i2c_sda from port group i2c3 to this pad." }
                      { value: "15", name: "port_spi8_spi_cs", desc: "Connect port spi_cs from port group spi8 to this pad." }
                      { value: "16", name: "port_spi8_spi_miso", desc: "Connect port spi_miso from port group spi8 to this pad." }
                      { value: "17", name: "port_spi8_spi_mosi", desc: "Connect port spi_mosi from port group spi8 to this pad." }
                      { value: "18", name: "port_spi8_spi_sck", desc: "Connect port spi_sck from port group spi8 to this pad." }
                      { value: "19", name: "port_spi9_spi_cs", desc: "Connect port spi_cs from port group spi9 to this pad." }
                      { value: "20", name: "port_spi9_spi_miso", desc: "Connect port spi_miso from port group spi9 to this pad." }
                      { value: "21", name: "port_spi9_spi_mosi", desc: "Connect port spi_mosi from port group spi9 to this pad." }
                      { value: "22", name: "port_spi9_spi_sck", desc: "Connect port spi_sck from port group spi9 to this pad." }
                  ]
              }
          ]
      }

      {
          name: PAD_MX_CAM0_8_CFG
          desc: '''
            Pad signal configuration.
          '''
          swaccess: "rw"
          fields: [
            {
                bits: "0"
                name: chip2pad
                desc: '''
                     The signal that connects to the pads TX driver
                '''
                swaccess: "rw"
                hwaccess: "hro"
                resval: "0"
            },
            {
                bits: "1"
                name: oen
                desc: '''
                     Output enable signal, active low
                '''
                swaccess: "rw"
                hwaccess: "hro"
                resval: "1"
            },
          ]
      }

       {
          name: PAD_MX_CAM0_8_MUX_SEL
          desc: '''
              Pad signal port multiplex selection for pad pad_mx_cam0_8. The programmed value defines which port
              is connected to the pad.
          '''
          swaccess: "rw"
          hwaccess: "hro"
          resval: 0
          fields: [
              {
                  bits: "4:0"
                  enum: [
                      { value: "0", name: "register", desc: "Connects the Pad to the internal configuration register."}
                      { value: "1", name: "port_IMU2_DRDY_gpio57", desc: "Connect port gpio57 from port group IMU2_DRDY to this pad." }
                      { value: "2", name: "port_cam0_cam_data0_i", desc: "Connect port cam_data0_i from port group cam0 to this pad." }
                      { value: "3", name: "port_cam0_cam_data1_i", desc: "Connect port cam_data1_i from port group cam0 to this pad." }
                      { value: "4", name: "port_cam0_cam_data2_i", desc: "Connect port cam_data2_i from port group cam0 to this pad." }
                      { value: "5", name: "port_cam0_cam_data3_i", desc: "Connect port cam_data3_i from port group cam0 to this pad." }
                      { value: "6", name: "port_cam0_cam_data4_i", desc: "Connect port cam_data4_i from port group cam0 to this pad." }
                      { value: "7", name: "port_cam0_cam_data5_i", desc: "Connect port cam_data5_i from port group cam0 to this pad." }
                      { value: "8", name: "port_cam0_cam_data6_i", desc: "Connect port cam_data6_i from port group cam0 to this pad." }
                      { value: "9", name: "port_cam0_cam_data7_i", desc: "Connect port cam_data7_i from port group cam0 to this pad." }
                      { value: "10", name: "port_cam0_cam_hsync", desc: "Connect port cam_hsync from port group cam0 to this pad." }
                      { value: "11", name: "port_cam0_cam_pclk", desc: "Connect port cam_pclk from port group cam0 to this pad." }
                      { value: "12", name: "port_cam0_cam_vsync", desc: "Connect port cam_vsync from port group cam0 to this pad." }
                      { value: "13", name: "port_i2c3_i2c_scl", desc: "Connect port i2c_scl from port group i2c3 to this pad." }
                      { value: "14", name: "port_i2c3_i2c_sda", desc: "Connect port i2c_sda from port group i2c3 to this pad." }
                      { value: "15", name: "port_spi8_spi_cs", desc: "Connect port spi_cs from port group spi8 to this pad." }
                      { value: "16", name: "port_spi8_spi_miso", desc: "Connect port spi_miso from port group spi8 to this pad." }
                      { value: "17", name: "port_spi8_spi_mosi", desc: "Connect port spi_mosi from port group spi8 to this pad." }
                      { value: "18", name: "port_spi8_spi_sck", desc: "Connect port spi_sck from port group spi8 to this pad." }
                      { value: "19", name: "port_spi9_spi_cs", desc: "Connect port spi_cs from port group spi9 to this pad." }
                      { value: "20", name: "port_spi9_spi_miso", desc: "Connect port spi_miso from port group spi9 to this pad." }
                      { value: "21", name: "port_spi9_spi_mosi", desc: "Connect port spi_mosi from port group spi9 to this pad." }
                      { value: "22", name: "port_spi9_spi_sck", desc: "Connect port spi_sck from port group spi9 to this pad." }
                  ]
              }
          ]
      }

      {
          name: PAD_MX_CAM0_9_CFG
          desc: '''
            Pad signal configuration.
          '''
          swaccess: "rw"
          fields: [
            {
                bits: "0"
                name: chip2pad
                desc: '''
                     The signal that connects to the pads TX driver
                '''
                swaccess: "rw"
                hwaccess: "hro"
                resval: "0"
            },
            {
                bits: "1"
                name: oen
                desc: '''
                     Output enable signal, active low
                '''
                swaccess: "rw"
                hwaccess: "hro"
                resval: "1"
            },
          ]
      }

       {
          name: PAD_MX_CAM0_9_MUX_SEL
          desc: '''
              Pad signal port multiplex selection for pad pad_mx_cam0_9. The programmed value defines which port
              is connected to the pad.
          '''
          swaccess: "rw"
          hwaccess: "hro"
          resval: 0
          fields: [
              {
                  bits: "4:0"
                  enum: [
                      { value: "0", name: "register", desc: "Connects the Pad to the internal configuration register."}
                      { value: "1", name: "port_IMU2_DRDY_gpio57", desc: "Connect port gpio57 from port group IMU2_DRDY to this pad." }
                      { value: "2", name: "port_cam0_cam_data0_i", desc: "Connect port cam_data0_i from port group cam0 to this pad." }
                      { value: "3", name: "port_cam0_cam_data1_i", desc: "Connect port cam_data1_i from port group cam0 to this pad." }
                      { value: "4", name: "port_cam0_cam_data2_i", desc: "Connect port cam_data2_i from port group cam0 to this pad." }
                      { value: "5", name: "port_cam0_cam_data3_i", desc: "Connect port cam_data3_i from port group cam0 to this pad." }
                      { value: "6", name: "port_cam0_cam_data4_i", desc: "Connect port cam_data4_i from port group cam0 to this pad." }
                      { value: "7", name: "port_cam0_cam_data5_i", desc: "Connect port cam_data5_i from port group cam0 to this pad." }
                      { value: "8", name: "port_cam0_cam_data6_i", desc: "Connect port cam_data6_i from port group cam0 to this pad." }
                      { value: "9", name: "port_cam0_cam_data7_i", desc: "Connect port cam_data7_i from port group cam0 to this pad." }
                      { value: "10", name: "port_cam0_cam_hsync", desc: "Connect port cam_hsync from port group cam0 to this pad." }
                      { value: "11", name: "port_cam0_cam_pclk", desc: "Connect port cam_pclk from port group cam0 to this pad." }
                      { value: "12", name: "port_cam0_cam_vsync", desc: "Connect port cam_vsync from port group cam0 to this pad." }
                      { value: "13", name: "port_i2c3_i2c_scl", desc: "Connect port i2c_scl from port group i2c3 to this pad." }
                      { value: "14", name: "port_i2c3_i2c_sda", desc: "Connect port i2c_sda from port group i2c3 to this pad." }
                      { value: "15", name: "port_spi8_spi_cs", desc: "Connect port spi_cs from port group spi8 to this pad." }
                      { value: "16", name: "port_spi8_spi_miso", desc: "Connect port spi_miso from port group spi8 to this pad." }
                      { value: "17", name: "port_spi8_spi_mosi", desc: "Connect port spi_mosi from port group spi8 to this pad." }
                      { value: "18", name: "port_spi8_spi_sck", desc: "Connect port spi_sck from port group spi8 to this pad." }
                      { value: "19", name: "port_spi9_spi_cs", desc: "Connect port spi_cs from port group spi9 to this pad." }
                      { value: "20", name: "port_spi9_spi_miso", desc: "Connect port spi_miso from port group spi9 to this pad." }
                      { value: "21", name: "port_spi9_spi_mosi", desc: "Connect port spi_mosi from port group spi9 to this pad." }
                      { value: "22", name: "port_spi9_spi_sck", desc: "Connect port spi_sck from port group spi9 to this pad." }
                  ]
              }
          ]
      }

      {
          name: PAD_MX_CAM0_10_CFG
          desc: '''
            Pad signal configuration.
          '''
          swaccess: "rw"
          fields: [
            {
                bits: "0"
                name: chip2pad
                desc: '''
                     The signal that connects to the pads TX driver
                '''
                swaccess: "rw"
                hwaccess: "hro"
                resval: "0"
            },
            {
                bits: "1"
                name: oen
                desc: '''
                     Output enable signal, active low
                '''
                swaccess: "rw"
                hwaccess: "hro"
                resval: "1"
            },
          ]
      }

       {
          name: PAD_MX_CAM0_10_MUX_SEL
          desc: '''
              Pad signal port multiplex selection for pad pad_mx_cam0_10. The programmed value defines which port
              is connected to the pad.
          '''
          swaccess: "rw"
          hwaccess: "hro"
          resval: 0
          fields: [
              {
                  bits: "4:0"
                  enum: [
                      { value: "0", name: "register", desc: "Connects the Pad to the internal configuration register."}
                      { value: "1", name: "port_IMU2_DRDY_gpio57", desc: "Connect port gpio57 from port group IMU2_DRDY to this pad." }
                      { value: "2", name: "port_cam0_cam_data0_i", desc: "Connect port cam_data0_i from port group cam0 to this pad." }
                      { value: "3", name: "port_cam0_cam_data1_i", desc: "Connect port cam_data1_i from port group cam0 to this pad." }
                      { value: "4", name: "port_cam0_cam_data2_i", desc: "Connect port cam_data2_i from port group cam0 to this pad." }
                      { value: "5", name: "port_cam0_cam_data3_i", desc: "Connect port cam_data3_i from port group cam0 to this pad." }
                      { value: "6", name: "port_cam0_cam_data4_i", desc: "Connect port cam_data4_i from port group cam0 to this pad." }
                      { value: "7", name: "port_cam0_cam_data5_i", desc: "Connect port cam_data5_i from port group cam0 to this pad." }
                      { value: "8", name: "port_cam0_cam_data6_i", desc: "Connect port cam_data6_i from port group cam0 to this pad." }
                      { value: "9", name: "port_cam0_cam_data7_i", desc: "Connect port cam_data7_i from port group cam0 to this pad." }
                      { value: "10", name: "port_cam0_cam_hsync", desc: "Connect port cam_hsync from port group cam0 to this pad." }
                      { value: "11", name: "port_cam0_cam_pclk", desc: "Connect port cam_pclk from port group cam0 to this pad." }
                      { value: "12", name: "port_cam0_cam_vsync", desc: "Connect port cam_vsync from port group cam0 to this pad." }
                      { value: "13", name: "port_i2c3_i2c_scl", desc: "Connect port i2c_scl from port group i2c3 to this pad." }
                      { value: "14", name: "port_i2c3_i2c_sda", desc: "Connect port i2c_sda from port group i2c3 to this pad." }
                      { value: "15", name: "port_spi8_spi_cs", desc: "Connect port spi_cs from port group spi8 to this pad." }
                      { value: "16", name: "port_spi8_spi_miso", desc: "Connect port spi_miso from port group spi8 to this pad." }
                      { value: "17", name: "port_spi8_spi_mosi", desc: "Connect port spi_mosi from port group spi8 to this pad." }
                      { value: "18", name: "port_spi8_spi_sck", desc: "Connect port spi_sck from port group spi8 to this pad." }
                      { value: "19", name: "port_spi9_spi_cs", desc: "Connect port spi_cs from port group spi9 to this pad." }
                      { value: "20", name: "port_spi9_spi_miso", desc: "Connect port spi_miso from port group spi9 to this pad." }
                      { value: "21", name: "port_spi9_spi_mosi", desc: "Connect port spi_mosi from port group spi9 to this pad." }
                      { value: "22", name: "port_spi9_spi_sck", desc: "Connect port spi_sck from port group spi9 to this pad." }
                  ]
              }
          ]
      }

      {
          name: PAD_MX_CAM1_0_CFG
          desc: '''
            Pad signal configuration.
          '''
          swaccess: "rw"
          fields: [
            {
                bits: "0"
                name: chip2pad
                desc: '''
                     The signal that connects to the pads TX driver
                '''
                swaccess: "rw"
                hwaccess: "hro"
                resval: "0"
            },
            {
                bits: "1"
                name: oen
                desc: '''
                     Output enable signal, active low
                '''
                swaccess: "rw"
                hwaccess: "hro"
                resval: "1"
            },
          ]
      }

       {
          name: PAD_MX_CAM1_0_MUX_SEL
          desc: '''
              Pad signal port multiplex selection for pad pad_mx_cam1_0. The programmed value defines which port
              is connected to the pad.
          '''
          swaccess: "rw"
          hwaccess: "hro"
          resval: 0
          fields: [
              {
                  bits: "4:0"
                  enum: [
                      { value: "0", name: "register", desc: "Connects the Pad to the internal configuration register."}
                      { value: "1", name: "port_SPI10_CS1_spi10_cs1", desc: "Connect port spi10_cs1 from port group SPI10_CS1 to this pad." }
                      { value: "2", name: "port_cam1_cam_data0_i", desc: "Connect port cam_data0_i from port group cam1 to this pad." }
                      { value: "3", name: "port_cam1_cam_data1_i", desc: "Connect port cam_data1_i from port group cam1 to this pad." }
                      { value: "4", name: "port_cam1_cam_data2_i", desc: "Connect port cam_data2_i from port group cam1 to this pad." }
                      { value: "5", name: "port_cam1_cam_data3_i", desc: "Connect port cam_data3_i from port group cam1 to this pad." }
                      { value: "6", name: "port_cam1_cam_data4_i", desc: "Connect port cam_data4_i from port group cam1 to this pad." }
                      { value: "7", name: "port_cam1_cam_data5_i", desc: "Connect port cam_data5_i from port group cam1 to this pad." }
                      { value: "8", name: "port_cam1_cam_data6_i", desc: "Connect port cam_data6_i from port group cam1 to this pad." }
                      { value: "9", name: "port_cam1_cam_data7_i", desc: "Connect port cam_data7_i from port group cam1 to this pad." }
                      { value: "10", name: "port_cam1_cam_hsync", desc: "Connect port cam_hsync from port group cam1 to this pad." }
                      { value: "11", name: "port_cam1_cam_pclk", desc: "Connect port cam_pclk from port group cam1 to this pad." }
                      { value: "12", name: "port_cam1_cam_vsync", desc: "Connect port cam_vsync from port group cam1 to this pad." }
                      { value: "13", name: "port_gpio58_gpio", desc: "Connect port gpio from port group gpio58 to this pad." }
                      { value: "14", name: "port_gpio59_gpio", desc: "Connect port gpio from port group gpio59 to this pad." }
                      { value: "15", name: "port_gpio60_gpio", desc: "Connect port gpio from port group gpio60 to this pad." }
                      { value: "16", name: "port_i2c4_i2c_scl", desc: "Connect port i2c_scl from port group i2c4 to this pad." }
                      { value: "17", name: "port_i2c4_i2c_sda", desc: "Connect port i2c_sda from port group i2c4 to this pad." }
                      { value: "18", name: "port_spi10_spi_cs", desc: "Connect port spi_cs from port group spi10 to this pad." }
                      { value: "19", name: "port_spi10_spi_miso", desc: "Connect port spi_miso from port group spi10 to this pad." }
                      { value: "20", name: "port_spi10_spi_mosi", desc: "Connect port spi_mosi from port group spi10 to this pad." }
                      { value: "21", name: "port_spi10_spi_sck", desc: "Connect port spi_sck from port group spi10 to this pad." }
                  ]
              }
          ]
      }

      {
          name: PAD_MX_CAM1_1_CFG
          desc: '''
            Pad signal configuration.
          '''
          swaccess: "rw"
          fields: [
            {
                bits: "0"
                name: chip2pad
                desc: '''
                     The signal that connects to the pads TX driver
                '''
                swaccess: "rw"
                hwaccess: "hro"
                resval: "0"
            },
            {
                bits: "1"
                name: oen
                desc: '''
                     Output enable signal, active low
                '''
                swaccess: "rw"
                hwaccess: "hro"
                resval: "1"
            },
          ]
      }

       {
          name: PAD_MX_CAM1_1_MUX_SEL
          desc: '''
              Pad signal port multiplex selection for pad pad_mx_cam1_1. The programmed value defines which port
              is connected to the pad.
          '''
          swaccess: "rw"
          hwaccess: "hro"
          resval: 0
          fields: [
              {
                  bits: "4:0"
                  enum: [
                      { value: "0", name: "register", desc: "Connects the Pad to the internal configuration register."}
                      { value: "1", name: "port_SPI10_CS1_spi10_cs1", desc: "Connect port spi10_cs1 from port group SPI10_CS1 to this pad." }
                      { value: "2", name: "port_cam1_cam_data0_i", desc: "Connect port cam_data0_i from port group cam1 to this pad." }
                      { value: "3", name: "port_cam1_cam_data1_i", desc: "Connect port cam_data1_i from port group cam1 to this pad." }
                      { value: "4", name: "port_cam1_cam_data2_i", desc: "Connect port cam_data2_i from port group cam1 to this pad." }
                      { value: "5", name: "port_cam1_cam_data3_i", desc: "Connect port cam_data3_i from port group cam1 to this pad." }
                      { value: "6", name: "port_cam1_cam_data4_i", desc: "Connect port cam_data4_i from port group cam1 to this pad." }
                      { value: "7", name: "port_cam1_cam_data5_i", desc: "Connect port cam_data5_i from port group cam1 to this pad." }
                      { value: "8", name: "port_cam1_cam_data6_i", desc: "Connect port cam_data6_i from port group cam1 to this pad." }
                      { value: "9", name: "port_cam1_cam_data7_i", desc: "Connect port cam_data7_i from port group cam1 to this pad." }
                      { value: "10", name: "port_cam1_cam_hsync", desc: "Connect port cam_hsync from port group cam1 to this pad." }
                      { value: "11", name: "port_cam1_cam_pclk", desc: "Connect port cam_pclk from port group cam1 to this pad." }
                      { value: "12", name: "port_cam1_cam_vsync", desc: "Connect port cam_vsync from port group cam1 to this pad." }
                      { value: "13", name: "port_gpio58_gpio", desc: "Connect port gpio from port group gpio58 to this pad." }
                      { value: "14", name: "port_gpio59_gpio", desc: "Connect port gpio from port group gpio59 to this pad." }
                      { value: "15", name: "port_gpio60_gpio", desc: "Connect port gpio from port group gpio60 to this pad." }
                      { value: "16", name: "port_i2c4_i2c_scl", desc: "Connect port i2c_scl from port group i2c4 to this pad." }
                      { value: "17", name: "port_i2c4_i2c_sda", desc: "Connect port i2c_sda from port group i2c4 to this pad." }
                      { value: "18", name: "port_spi10_spi_cs", desc: "Connect port spi_cs from port group spi10 to this pad." }
                      { value: "19", name: "port_spi10_spi_miso", desc: "Connect port spi_miso from port group spi10 to this pad." }
                      { value: "20", name: "port_spi10_spi_mosi", desc: "Connect port spi_mosi from port group spi10 to this pad." }
                      { value: "21", name: "port_spi10_spi_sck", desc: "Connect port spi_sck from port group spi10 to this pad." }
                  ]
              }
          ]
      }

      {
          name: PAD_MX_CAM1_2_CFG
          desc: '''
            Pad signal configuration.
          '''
          swaccess: "rw"
          fields: [
            {
                bits: "0"
                name: chip2pad
                desc: '''
                     The signal that connects to the pads TX driver
                '''
                swaccess: "rw"
                hwaccess: "hro"
                resval: "0"
            },
            {
                bits: "1"
                name: oen
                desc: '''
                     Output enable signal, active low
                '''
                swaccess: "rw"
                hwaccess: "hro"
                resval: "1"
            },
          ]
      }

       {
          name: PAD_MX_CAM1_2_MUX_SEL
          desc: '''
              Pad signal port multiplex selection for pad pad_mx_cam1_2. The programmed value defines which port
              is connected to the pad.
          '''
          swaccess: "rw"
          hwaccess: "hro"
          resval: 0
          fields: [
              {
                  bits: "4:0"
                  enum: [
                      { value: "0", name: "register", desc: "Connects the Pad to the internal configuration register."}
                      { value: "1", name: "port_SPI10_CS1_spi10_cs1", desc: "Connect port spi10_cs1 from port group SPI10_CS1 to this pad." }
                      { value: "2", name: "port_cam1_cam_data0_i", desc: "Connect port cam_data0_i from port group cam1 to this pad." }
                      { value: "3", name: "port_cam1_cam_data1_i", desc: "Connect port cam_data1_i from port group cam1 to this pad." }
                      { value: "4", name: "port_cam1_cam_data2_i", desc: "Connect port cam_data2_i from port group cam1 to this pad." }
                      { value: "5", name: "port_cam1_cam_data3_i", desc: "Connect port cam_data3_i from port group cam1 to this pad." }
                      { value: "6", name: "port_cam1_cam_data4_i", desc: "Connect port cam_data4_i from port group cam1 to this pad." }
                      { value: "7", name: "port_cam1_cam_data5_i", desc: "Connect port cam_data5_i from port group cam1 to this pad." }
                      { value: "8", name: "port_cam1_cam_data6_i", desc: "Connect port cam_data6_i from port group cam1 to this pad." }
                      { value: "9", name: "port_cam1_cam_data7_i", desc: "Connect port cam_data7_i from port group cam1 to this pad." }
                      { value: "10", name: "port_cam1_cam_hsync", desc: "Connect port cam_hsync from port group cam1 to this pad." }
                      { value: "11", name: "port_cam1_cam_pclk", desc: "Connect port cam_pclk from port group cam1 to this pad." }
                      { value: "12", name: "port_cam1_cam_vsync", desc: "Connect port cam_vsync from port group cam1 to this pad." }
                      { value: "13", name: "port_gpio58_gpio", desc: "Connect port gpio from port group gpio58 to this pad." }
                      { value: "14", name: "port_gpio59_gpio", desc: "Connect port gpio from port group gpio59 to this pad." }
                      { value: "15", name: "port_gpio60_gpio", desc: "Connect port gpio from port group gpio60 to this pad." }
                      { value: "16", name: "port_i2c4_i2c_scl", desc: "Connect port i2c_scl from port group i2c4 to this pad." }
                      { value: "17", name: "port_i2c4_i2c_sda", desc: "Connect port i2c_sda from port group i2c4 to this pad." }
                      { value: "18", name: "port_spi10_spi_cs", desc: "Connect port spi_cs from port group spi10 to this pad." }
                      { value: "19", name: "port_spi10_spi_miso", desc: "Connect port spi_miso from port group spi10 to this pad." }
                      { value: "20", name: "port_spi10_spi_mosi", desc: "Connect port spi_mosi from port group spi10 to this pad." }
                      { value: "21", name: "port_spi10_spi_sck", desc: "Connect port spi_sck from port group spi10 to this pad." }
                  ]
              }
          ]
      }

      {
          name: PAD_MX_CAM1_3_CFG
          desc: '''
            Pad signal configuration.
          '''
          swaccess: "rw"
          fields: [
            {
                bits: "0"
                name: chip2pad
                desc: '''
                     The signal that connects to the pads TX driver
                '''
                swaccess: "rw"
                hwaccess: "hro"
                resval: "0"
            },
            {
                bits: "1"
                name: oen
                desc: '''
                     Output enable signal, active low
                '''
                swaccess: "rw"
                hwaccess: "hro"
                resval: "1"
            },
          ]
      }

       {
          name: PAD_MX_CAM1_3_MUX_SEL
          desc: '''
              Pad signal port multiplex selection for pad pad_mx_cam1_3. The programmed value defines which port
              is connected to the pad.
          '''
          swaccess: "rw"
          hwaccess: "hro"
          resval: 0
          fields: [
              {
                  bits: "4:0"
                  enum: [
                      { value: "0", name: "register", desc: "Connects the Pad to the internal configuration register."}
                      { value: "1", name: "port_SPI10_CS1_spi10_cs1", desc: "Connect port spi10_cs1 from port group SPI10_CS1 to this pad." }
                      { value: "2", name: "port_cam1_cam_data0_i", desc: "Connect port cam_data0_i from port group cam1 to this pad." }
                      { value: "3", name: "port_cam1_cam_data1_i", desc: "Connect port cam_data1_i from port group cam1 to this pad." }
                      { value: "4", name: "port_cam1_cam_data2_i", desc: "Connect port cam_data2_i from port group cam1 to this pad." }
                      { value: "5", name: "port_cam1_cam_data3_i", desc: "Connect port cam_data3_i from port group cam1 to this pad." }
                      { value: "6", name: "port_cam1_cam_data4_i", desc: "Connect port cam_data4_i from port group cam1 to this pad." }
                      { value: "7", name: "port_cam1_cam_data5_i", desc: "Connect port cam_data5_i from port group cam1 to this pad." }
                      { value: "8", name: "port_cam1_cam_data6_i", desc: "Connect port cam_data6_i from port group cam1 to this pad." }
                      { value: "9", name: "port_cam1_cam_data7_i", desc: "Connect port cam_data7_i from port group cam1 to this pad." }
                      { value: "10", name: "port_cam1_cam_hsync", desc: "Connect port cam_hsync from port group cam1 to this pad." }
                      { value: "11", name: "port_cam1_cam_pclk", desc: "Connect port cam_pclk from port group cam1 to this pad." }
                      { value: "12", name: "port_cam1_cam_vsync", desc: "Connect port cam_vsync from port group cam1 to this pad." }
                      { value: "13", name: "port_gpio58_gpio", desc: "Connect port gpio from port group gpio58 to this pad." }
                      { value: "14", name: "port_gpio59_gpio", desc: "Connect port gpio from port group gpio59 to this pad." }
                      { value: "15", name: "port_gpio60_gpio", desc: "Connect port gpio from port group gpio60 to this pad." }
                      { value: "16", name: "port_i2c4_i2c_scl", desc: "Connect port i2c_scl from port group i2c4 to this pad." }
                      { value: "17", name: "port_i2c4_i2c_sda", desc: "Connect port i2c_sda from port group i2c4 to this pad." }
                      { value: "18", name: "port_spi10_spi_cs", desc: "Connect port spi_cs from port group spi10 to this pad." }
                      { value: "19", name: "port_spi10_spi_miso", desc: "Connect port spi_miso from port group spi10 to this pad." }
                      { value: "20", name: "port_spi10_spi_mosi", desc: "Connect port spi_mosi from port group spi10 to this pad." }
                      { value: "21", name: "port_spi10_spi_sck", desc: "Connect port spi_sck from port group spi10 to this pad." }
                  ]
              }
          ]
      }

      {
          name: PAD_MX_CAM1_4_CFG
          desc: '''
            Pad signal configuration.
          '''
          swaccess: "rw"
          fields: [
            {
                bits: "0"
                name: chip2pad
                desc: '''
                     The signal that connects to the pads TX driver
                '''
                swaccess: "rw"
                hwaccess: "hro"
                resval: "0"
            },
            {
                bits: "1"
                name: oen
                desc: '''
                     Output enable signal, active low
                '''
                swaccess: "rw"
                hwaccess: "hro"
                resval: "1"
            },
          ]
      }

       {
          name: PAD_MX_CAM1_4_MUX_SEL
          desc: '''
              Pad signal port multiplex selection for pad pad_mx_cam1_4. The programmed value defines which port
              is connected to the pad.
          '''
          swaccess: "rw"
          hwaccess: "hro"
          resval: 0
          fields: [
              {
                  bits: "4:0"
                  enum: [
                      { value: "0", name: "register", desc: "Connects the Pad to the internal configuration register."}
                      { value: "1", name: "port_SPI10_CS1_spi10_cs1", desc: "Connect port spi10_cs1 from port group SPI10_CS1 to this pad." }
                      { value: "2", name: "port_cam1_cam_data0_i", desc: "Connect port cam_data0_i from port group cam1 to this pad." }
                      { value: "3", name: "port_cam1_cam_data1_i", desc: "Connect port cam_data1_i from port group cam1 to this pad." }
                      { value: "4", name: "port_cam1_cam_data2_i", desc: "Connect port cam_data2_i from port group cam1 to this pad." }
                      { value: "5", name: "port_cam1_cam_data3_i", desc: "Connect port cam_data3_i from port group cam1 to this pad." }
                      { value: "6", name: "port_cam1_cam_data4_i", desc: "Connect port cam_data4_i from port group cam1 to this pad." }
                      { value: "7", name: "port_cam1_cam_data5_i", desc: "Connect port cam_data5_i from port group cam1 to this pad." }
                      { value: "8", name: "port_cam1_cam_data6_i", desc: "Connect port cam_data6_i from port group cam1 to this pad." }
                      { value: "9", name: "port_cam1_cam_data7_i", desc: "Connect port cam_data7_i from port group cam1 to this pad." }
                      { value: "10", name: "port_cam1_cam_hsync", desc: "Connect port cam_hsync from port group cam1 to this pad." }
                      { value: "11", name: "port_cam1_cam_pclk", desc: "Connect port cam_pclk from port group cam1 to this pad." }
                      { value: "12", name: "port_cam1_cam_vsync", desc: "Connect port cam_vsync from port group cam1 to this pad." }
                      { value: "13", name: "port_gpio58_gpio", desc: "Connect port gpio from port group gpio58 to this pad." }
                      { value: "14", name: "port_gpio59_gpio", desc: "Connect port gpio from port group gpio59 to this pad." }
                      { value: "15", name: "port_gpio60_gpio", desc: "Connect port gpio from port group gpio60 to this pad." }
                      { value: "16", name: "port_i2c4_i2c_scl", desc: "Connect port i2c_scl from port group i2c4 to this pad." }
                      { value: "17", name: "port_i2c4_i2c_sda", desc: "Connect port i2c_sda from port group i2c4 to this pad." }
                      { value: "18", name: "port_spi10_spi_cs", desc: "Connect port spi_cs from port group spi10 to this pad." }
                      { value: "19", name: "port_spi10_spi_miso", desc: "Connect port spi_miso from port group spi10 to this pad." }
                      { value: "20", name: "port_spi10_spi_mosi", desc: "Connect port spi_mosi from port group spi10 to this pad." }
                      { value: "21", name: "port_spi10_spi_sck", desc: "Connect port spi_sck from port group spi10 to this pad." }
                  ]
              }
          ]
      }

      {
          name: PAD_MX_CAM1_5_CFG
          desc: '''
            Pad signal configuration.
          '''
          swaccess: "rw"
          fields: [
            {
                bits: "0"
                name: chip2pad
                desc: '''
                     The signal that connects to the pads TX driver
                '''
                swaccess: "rw"
                hwaccess: "hro"
                resval: "0"
            },
            {
                bits: "1"
                name: oen
                desc: '''
                     Output enable signal, active low
                '''
                swaccess: "rw"
                hwaccess: "hro"
                resval: "1"
            },
          ]
      }

       {
          name: PAD_MX_CAM1_5_MUX_SEL
          desc: '''
              Pad signal port multiplex selection for pad pad_mx_cam1_5. The programmed value defines which port
              is connected to the pad.
          '''
          swaccess: "rw"
          hwaccess: "hro"
          resval: 0
          fields: [
              {
                  bits: "4:0"
                  enum: [
                      { value: "0", name: "register", desc: "Connects the Pad to the internal configuration register."}
                      { value: "1", name: "port_SPI10_CS1_spi10_cs1", desc: "Connect port spi10_cs1 from port group SPI10_CS1 to this pad." }
                      { value: "2", name: "port_cam1_cam_data0_i", desc: "Connect port cam_data0_i from port group cam1 to this pad." }
                      { value: "3", name: "port_cam1_cam_data1_i", desc: "Connect port cam_data1_i from port group cam1 to this pad." }
                      { value: "4", name: "port_cam1_cam_data2_i", desc: "Connect port cam_data2_i from port group cam1 to this pad." }
                      { value: "5", name: "port_cam1_cam_data3_i", desc: "Connect port cam_data3_i from port group cam1 to this pad." }
                      { value: "6", name: "port_cam1_cam_data4_i", desc: "Connect port cam_data4_i from port group cam1 to this pad." }
                      { value: "7", name: "port_cam1_cam_data5_i", desc: "Connect port cam_data5_i from port group cam1 to this pad." }
                      { value: "8", name: "port_cam1_cam_data6_i", desc: "Connect port cam_data6_i from port group cam1 to this pad." }
                      { value: "9", name: "port_cam1_cam_data7_i", desc: "Connect port cam_data7_i from port group cam1 to this pad." }
                      { value: "10", name: "port_cam1_cam_hsync", desc: "Connect port cam_hsync from port group cam1 to this pad." }
                      { value: "11", name: "port_cam1_cam_pclk", desc: "Connect port cam_pclk from port group cam1 to this pad." }
                      { value: "12", name: "port_cam1_cam_vsync", desc: "Connect port cam_vsync from port group cam1 to this pad." }
                      { value: "13", name: "port_gpio58_gpio", desc: "Connect port gpio from port group gpio58 to this pad." }
                      { value: "14", name: "port_gpio59_gpio", desc: "Connect port gpio from port group gpio59 to this pad." }
                      { value: "15", name: "port_gpio60_gpio", desc: "Connect port gpio from port group gpio60 to this pad." }
                      { value: "16", name: "port_i2c4_i2c_scl", desc: "Connect port i2c_scl from port group i2c4 to this pad." }
                      { value: "17", name: "port_i2c4_i2c_sda", desc: "Connect port i2c_sda from port group i2c4 to this pad." }
                      { value: "18", name: "port_spi10_spi_cs", desc: "Connect port spi_cs from port group spi10 to this pad." }
                      { value: "19", name: "port_spi10_spi_miso", desc: "Connect port spi_miso from port group spi10 to this pad." }
                      { value: "20", name: "port_spi10_spi_mosi", desc: "Connect port spi_mosi from port group spi10 to this pad." }
                      { value: "21", name: "port_spi10_spi_sck", desc: "Connect port spi_sck from port group spi10 to this pad." }
                  ]
              }
          ]
      }

      {
          name: PAD_MX_CAM1_6_CFG
          desc: '''
            Pad signal configuration.
          '''
          swaccess: "rw"
          fields: [
            {
                bits: "0"
                name: chip2pad
                desc: '''
                     The signal that connects to the pads TX driver
                '''
                swaccess: "rw"
                hwaccess: "hro"
                resval: "0"
            },
            {
                bits: "1"
                name: oen
                desc: '''
                     Output enable signal, active low
                '''
                swaccess: "rw"
                hwaccess: "hro"
                resval: "1"
            },
          ]
      }

       {
          name: PAD_MX_CAM1_6_MUX_SEL
          desc: '''
              Pad signal port multiplex selection for pad pad_mx_cam1_6. The programmed value defines which port
              is connected to the pad.
          '''
          swaccess: "rw"
          hwaccess: "hro"
          resval: 0
          fields: [
              {
                  bits: "4:0"
                  enum: [
                      { value: "0", name: "register", desc: "Connects the Pad to the internal configuration register."}
                      { value: "1", name: "port_SPI10_CS1_spi10_cs1", desc: "Connect port spi10_cs1 from port group SPI10_CS1 to this pad." }
                      { value: "2", name: "port_cam1_cam_data0_i", desc: "Connect port cam_data0_i from port group cam1 to this pad." }
                      { value: "3", name: "port_cam1_cam_data1_i", desc: "Connect port cam_data1_i from port group cam1 to this pad." }
                      { value: "4", name: "port_cam1_cam_data2_i", desc: "Connect port cam_data2_i from port group cam1 to this pad." }
                      { value: "5", name: "port_cam1_cam_data3_i", desc: "Connect port cam_data3_i from port group cam1 to this pad." }
                      { value: "6", name: "port_cam1_cam_data4_i", desc: "Connect port cam_data4_i from port group cam1 to this pad." }
                      { value: "7", name: "port_cam1_cam_data5_i", desc: "Connect port cam_data5_i from port group cam1 to this pad." }
                      { value: "8", name: "port_cam1_cam_data6_i", desc: "Connect port cam_data6_i from port group cam1 to this pad." }
                      { value: "9", name: "port_cam1_cam_data7_i", desc: "Connect port cam_data7_i from port group cam1 to this pad." }
                      { value: "10", name: "port_cam1_cam_hsync", desc: "Connect port cam_hsync from port group cam1 to this pad." }
                      { value: "11", name: "port_cam1_cam_pclk", desc: "Connect port cam_pclk from port group cam1 to this pad." }
                      { value: "12", name: "port_cam1_cam_vsync", desc: "Connect port cam_vsync from port group cam1 to this pad." }
                      { value: "13", name: "port_gpio58_gpio", desc: "Connect port gpio from port group gpio58 to this pad." }
                      { value: "14", name: "port_gpio59_gpio", desc: "Connect port gpio from port group gpio59 to this pad." }
                      { value: "15", name: "port_gpio60_gpio", desc: "Connect port gpio from port group gpio60 to this pad." }
                      { value: "16", name: "port_i2c4_i2c_scl", desc: "Connect port i2c_scl from port group i2c4 to this pad." }
                      { value: "17", name: "port_i2c4_i2c_sda", desc: "Connect port i2c_sda from port group i2c4 to this pad." }
                      { value: "18", name: "port_spi10_spi_cs", desc: "Connect port spi_cs from port group spi10 to this pad." }
                      { value: "19", name: "port_spi10_spi_miso", desc: "Connect port spi_miso from port group spi10 to this pad." }
                      { value: "20", name: "port_spi10_spi_mosi", desc: "Connect port spi_mosi from port group spi10 to this pad." }
                      { value: "21", name: "port_spi10_spi_sck", desc: "Connect port spi_sck from port group spi10 to this pad." }
                  ]
              }
          ]
      }

      {
          name: PAD_MX_CAM1_7_CFG
          desc: '''
            Pad signal configuration.
          '''
          swaccess: "rw"
          fields: [
            {
                bits: "0"
                name: chip2pad
                desc: '''
                     The signal that connects to the pads TX driver
                '''
                swaccess: "rw"
                hwaccess: "hro"
                resval: "0"
            },
            {
                bits: "1"
                name: oen
                desc: '''
                     Output enable signal, active low
                '''
                swaccess: "rw"
                hwaccess: "hro"
                resval: "1"
            },
          ]
      }

       {
          name: PAD_MX_CAM1_7_MUX_SEL
          desc: '''
              Pad signal port multiplex selection for pad pad_mx_cam1_7. The programmed value defines which port
              is connected to the pad.
          '''
          swaccess: "rw"
          hwaccess: "hro"
          resval: 0
          fields: [
              {
                  bits: "4:0"
                  enum: [
                      { value: "0", name: "register", desc: "Connects the Pad to the internal configuration register."}
                      { value: "1", name: "port_SPI10_CS1_spi10_cs1", desc: "Connect port spi10_cs1 from port group SPI10_CS1 to this pad." }
                      { value: "2", name: "port_cam1_cam_data0_i", desc: "Connect port cam_data0_i from port group cam1 to this pad." }
                      { value: "3", name: "port_cam1_cam_data1_i", desc: "Connect port cam_data1_i from port group cam1 to this pad." }
                      { value: "4", name: "port_cam1_cam_data2_i", desc: "Connect port cam_data2_i from port group cam1 to this pad." }
                      { value: "5", name: "port_cam1_cam_data3_i", desc: "Connect port cam_data3_i from port group cam1 to this pad." }
                      { value: "6", name: "port_cam1_cam_data4_i", desc: "Connect port cam_data4_i from port group cam1 to this pad." }
                      { value: "7", name: "port_cam1_cam_data5_i", desc: "Connect port cam_data5_i from port group cam1 to this pad." }
                      { value: "8", name: "port_cam1_cam_data6_i", desc: "Connect port cam_data6_i from port group cam1 to this pad." }
                      { value: "9", name: "port_cam1_cam_data7_i", desc: "Connect port cam_data7_i from port group cam1 to this pad." }
                      { value: "10", name: "port_cam1_cam_hsync", desc: "Connect port cam_hsync from port group cam1 to this pad." }
                      { value: "11", name: "port_cam1_cam_pclk", desc: "Connect port cam_pclk from port group cam1 to this pad." }
                      { value: "12", name: "port_cam1_cam_vsync", desc: "Connect port cam_vsync from port group cam1 to this pad." }
                      { value: "13", name: "port_gpio58_gpio", desc: "Connect port gpio from port group gpio58 to this pad." }
                      { value: "14", name: "port_gpio59_gpio", desc: "Connect port gpio from port group gpio59 to this pad." }
                      { value: "15", name: "port_gpio60_gpio", desc: "Connect port gpio from port group gpio60 to this pad." }
                      { value: "16", name: "port_i2c4_i2c_scl", desc: "Connect port i2c_scl from port group i2c4 to this pad." }
                      { value: "17", name: "port_i2c4_i2c_sda", desc: "Connect port i2c_sda from port group i2c4 to this pad." }
                      { value: "18", name: "port_spi10_spi_cs", desc: "Connect port spi_cs from port group spi10 to this pad." }
                      { value: "19", name: "port_spi10_spi_miso", desc: "Connect port spi_miso from port group spi10 to this pad." }
                      { value: "20", name: "port_spi10_spi_mosi", desc: "Connect port spi_mosi from port group spi10 to this pad." }
                      { value: "21", name: "port_spi10_spi_sck", desc: "Connect port spi_sck from port group spi10 to this pad." }
                  ]
              }
          ]
      }

      {
          name: PAD_MX_CAM1_8_CFG
          desc: '''
            Pad signal configuration.
          '''
          swaccess: "rw"
          fields: [
            {
                bits: "0"
                name: chip2pad
                desc: '''
                     The signal that connects to the pads TX driver
                '''
                swaccess: "rw"
                hwaccess: "hro"
                resval: "0"
            },
            {
                bits: "1"
                name: oen
                desc: '''
                     Output enable signal, active low
                '''
                swaccess: "rw"
                hwaccess: "hro"
                resval: "1"
            },
          ]
      }

       {
          name: PAD_MX_CAM1_8_MUX_SEL
          desc: '''
              Pad signal port multiplex selection for pad pad_mx_cam1_8. The programmed value defines which port
              is connected to the pad.
          '''
          swaccess: "rw"
          hwaccess: "hro"
          resval: 0
          fields: [
              {
                  bits: "4:0"
                  enum: [
                      { value: "0", name: "register", desc: "Connects the Pad to the internal configuration register."}
                      { value: "1", name: "port_SPI10_CS1_spi10_cs1", desc: "Connect port spi10_cs1 from port group SPI10_CS1 to this pad." }
                      { value: "2", name: "port_cam1_cam_data0_i", desc: "Connect port cam_data0_i from port group cam1 to this pad." }
                      { value: "3", name: "port_cam1_cam_data1_i", desc: "Connect port cam_data1_i from port group cam1 to this pad." }
                      { value: "4", name: "port_cam1_cam_data2_i", desc: "Connect port cam_data2_i from port group cam1 to this pad." }
                      { value: "5", name: "port_cam1_cam_data3_i", desc: "Connect port cam_data3_i from port group cam1 to this pad." }
                      { value: "6", name: "port_cam1_cam_data4_i", desc: "Connect port cam_data4_i from port group cam1 to this pad." }
                      { value: "7", name: "port_cam1_cam_data5_i", desc: "Connect port cam_data5_i from port group cam1 to this pad." }
                      { value: "8", name: "port_cam1_cam_data6_i", desc: "Connect port cam_data6_i from port group cam1 to this pad." }
                      { value: "9", name: "port_cam1_cam_data7_i", desc: "Connect port cam_data7_i from port group cam1 to this pad." }
                      { value: "10", name: "port_cam1_cam_hsync", desc: "Connect port cam_hsync from port group cam1 to this pad." }
                      { value: "11", name: "port_cam1_cam_pclk", desc: "Connect port cam_pclk from port group cam1 to this pad." }
                      { value: "12", name: "port_cam1_cam_vsync", desc: "Connect port cam_vsync from port group cam1 to this pad." }
                      { value: "13", name: "port_gpio58_gpio", desc: "Connect port gpio from port group gpio58 to this pad." }
                      { value: "14", name: "port_gpio59_gpio", desc: "Connect port gpio from port group gpio59 to this pad." }
                      { value: "15", name: "port_gpio60_gpio", desc: "Connect port gpio from port group gpio60 to this pad." }
                      { value: "16", name: "port_i2c4_i2c_scl", desc: "Connect port i2c_scl from port group i2c4 to this pad." }
                      { value: "17", name: "port_i2c4_i2c_sda", desc: "Connect port i2c_sda from port group i2c4 to this pad." }
                      { value: "18", name: "port_spi10_spi_cs", desc: "Connect port spi_cs from port group spi10 to this pad." }
                      { value: "19", name: "port_spi10_spi_miso", desc: "Connect port spi_miso from port group spi10 to this pad." }
                      { value: "20", name: "port_spi10_spi_mosi", desc: "Connect port spi_mosi from port group spi10 to this pad." }
                      { value: "21", name: "port_spi10_spi_sck", desc: "Connect port spi_sck from port group spi10 to this pad." }
                  ]
              }
          ]
      }

      {
          name: PAD_MX_CAM1_9_CFG
          desc: '''
            Pad signal configuration.
          '''
          swaccess: "rw"
          fields: [
            {
                bits: "0"
                name: chip2pad
                desc: '''
                     The signal that connects to the pads TX driver
                '''
                swaccess: "rw"
                hwaccess: "hro"
                resval: "0"
            },
            {
                bits: "1"
                name: oen
                desc: '''
                     Output enable signal, active low
                '''
                swaccess: "rw"
                hwaccess: "hro"
                resval: "1"
            },
          ]
      }

       {
          name: PAD_MX_CAM1_9_MUX_SEL
          desc: '''
              Pad signal port multiplex selection for pad pad_mx_cam1_9. The programmed value defines which port
              is connected to the pad.
          '''
          swaccess: "rw"
          hwaccess: "hro"
          resval: 0
          fields: [
              {
                  bits: "4:0"
                  enum: [
                      { value: "0", name: "register", desc: "Connects the Pad to the internal configuration register."}
                      { value: "1", name: "port_SPI10_CS1_spi10_cs1", desc: "Connect port spi10_cs1 from port group SPI10_CS1 to this pad." }
                      { value: "2", name: "port_cam1_cam_data0_i", desc: "Connect port cam_data0_i from port group cam1 to this pad." }
                      { value: "3", name: "port_cam1_cam_data1_i", desc: "Connect port cam_data1_i from port group cam1 to this pad." }
                      { value: "4", name: "port_cam1_cam_data2_i", desc: "Connect port cam_data2_i from port group cam1 to this pad." }
                      { value: "5", name: "port_cam1_cam_data3_i", desc: "Connect port cam_data3_i from port group cam1 to this pad." }
                      { value: "6", name: "port_cam1_cam_data4_i", desc: "Connect port cam_data4_i from port group cam1 to this pad." }
                      { value: "7", name: "port_cam1_cam_data5_i", desc: "Connect port cam_data5_i from port group cam1 to this pad." }
                      { value: "8", name: "port_cam1_cam_data6_i", desc: "Connect port cam_data6_i from port group cam1 to this pad." }
                      { value: "9", name: "port_cam1_cam_data7_i", desc: "Connect port cam_data7_i from port group cam1 to this pad." }
                      { value: "10", name: "port_cam1_cam_hsync", desc: "Connect port cam_hsync from port group cam1 to this pad." }
                      { value: "11", name: "port_cam1_cam_pclk", desc: "Connect port cam_pclk from port group cam1 to this pad." }
                      { value: "12", name: "port_cam1_cam_vsync", desc: "Connect port cam_vsync from port group cam1 to this pad." }
                      { value: "13", name: "port_gpio58_gpio", desc: "Connect port gpio from port group gpio58 to this pad." }
                      { value: "14", name: "port_gpio59_gpio", desc: "Connect port gpio from port group gpio59 to this pad." }
                      { value: "15", name: "port_gpio60_gpio", desc: "Connect port gpio from port group gpio60 to this pad." }
                      { value: "16", name: "port_i2c4_i2c_scl", desc: "Connect port i2c_scl from port group i2c4 to this pad." }
                      { value: "17", name: "port_i2c4_i2c_sda", desc: "Connect port i2c_sda from port group i2c4 to this pad." }
                      { value: "18", name: "port_spi10_spi_cs", desc: "Connect port spi_cs from port group spi10 to this pad." }
                      { value: "19", name: "port_spi10_spi_miso", desc: "Connect port spi_miso from port group spi10 to this pad." }
                      { value: "20", name: "port_spi10_spi_mosi", desc: "Connect port spi_mosi from port group spi10 to this pad." }
                      { value: "21", name: "port_spi10_spi_sck", desc: "Connect port spi_sck from port group spi10 to this pad." }
                  ]
              }
          ]
      }

      {
          name: PAD_MX_CAM1_10_CFG
          desc: '''
            Pad signal configuration.
          '''
          swaccess: "rw"
          fields: [
            {
                bits: "0"
                name: chip2pad
                desc: '''
                     The signal that connects to the pads TX driver
                '''
                swaccess: "rw"
                hwaccess: "hro"
                resval: "0"
            },
            {
                bits: "1"
                name: oen
                desc: '''
                     Output enable signal, active low
                '''
                swaccess: "rw"
                hwaccess: "hro"
                resval: "1"
            },
          ]
      }

       {
          name: PAD_MX_CAM1_10_MUX_SEL
          desc: '''
              Pad signal port multiplex selection for pad pad_mx_cam1_10. The programmed value defines which port
              is connected to the pad.
          '''
          swaccess: "rw"
          hwaccess: "hro"
          resval: 0
          fields: [
              {
                  bits: "4:0"
                  enum: [
                      { value: "0", name: "register", desc: "Connects the Pad to the internal configuration register."}
                      { value: "1", name: "port_SPI10_CS1_spi10_cs1", desc: "Connect port spi10_cs1 from port group SPI10_CS1 to this pad." }
                      { value: "2", name: "port_cam1_cam_data0_i", desc: "Connect port cam_data0_i from port group cam1 to this pad." }
                      { value: "3", name: "port_cam1_cam_data1_i", desc: "Connect port cam_data1_i from port group cam1 to this pad." }
                      { value: "4", name: "port_cam1_cam_data2_i", desc: "Connect port cam_data2_i from port group cam1 to this pad." }
                      { value: "5", name: "port_cam1_cam_data3_i", desc: "Connect port cam_data3_i from port group cam1 to this pad." }
                      { value: "6", name: "port_cam1_cam_data4_i", desc: "Connect port cam_data4_i from port group cam1 to this pad." }
                      { value: "7", name: "port_cam1_cam_data5_i", desc: "Connect port cam_data5_i from port group cam1 to this pad." }
                      { value: "8", name: "port_cam1_cam_data6_i", desc: "Connect port cam_data6_i from port group cam1 to this pad." }
                      { value: "9", name: "port_cam1_cam_data7_i", desc: "Connect port cam_data7_i from port group cam1 to this pad." }
                      { value: "10", name: "port_cam1_cam_hsync", desc: "Connect port cam_hsync from port group cam1 to this pad." }
                      { value: "11", name: "port_cam1_cam_pclk", desc: "Connect port cam_pclk from port group cam1 to this pad." }
                      { value: "12", name: "port_cam1_cam_vsync", desc: "Connect port cam_vsync from port group cam1 to this pad." }
                      { value: "13", name: "port_gpio58_gpio", desc: "Connect port gpio from port group gpio58 to this pad." }
                      { value: "14", name: "port_gpio59_gpio", desc: "Connect port gpio from port group gpio59 to this pad." }
                      { value: "15", name: "port_gpio60_gpio", desc: "Connect port gpio from port group gpio60 to this pad." }
                      { value: "16", name: "port_i2c4_i2c_scl", desc: "Connect port i2c_scl from port group i2c4 to this pad." }
                      { value: "17", name: "port_i2c4_i2c_sda", desc: "Connect port i2c_sda from port group i2c4 to this pad." }
                      { value: "18", name: "port_spi10_spi_cs", desc: "Connect port spi_cs from port group spi10 to this pad." }
                      { value: "19", name: "port_spi10_spi_miso", desc: "Connect port spi_miso from port group spi10 to this pad." }
                      { value: "20", name: "port_spi10_spi_mosi", desc: "Connect port spi_mosi from port group spi10 to this pad." }
                      { value: "21", name: "port_spi10_spi_sck", desc: "Connect port spi_sck from port group spi10 to this pad." }
                  ]
              }
          ]
      }

      {
          name: PAD_MX_SDIO1_0_CFG
          desc: '''
            Pad signal configuration.
          '''
          swaccess: "rw"
          fields: [
            {
                bits: "0"
                name: chip2pad
                desc: '''
                     The signal that connects to the pads TX driver
                '''
                swaccess: "rw"
                hwaccess: "hro"
                resval: "0"
            },
            {
                bits: "1"
                name: oen
                desc: '''
                     Output enable signal, active low
                '''
                swaccess: "rw"
                hwaccess: "hro"
                resval: "1"
            },
          ]
      }

       {
          name: PAD_MX_SDIO1_0_MUX_SEL
          desc: '''
              Pad signal port multiplex selection for pad pad_mx_sdio1_0. The programmed value defines which port
              is connected to the pad.
          '''
          swaccess: "rw"
          hwaccess: "hro"
          resval: 0
          fields: [
              {
                  bits: "3:0"
                  enum: [
                      { value: "0", name: "register", desc: "Connects the Pad to the internal configuration register."}
                      { value: "1", name: "port_gpio61_gpio", desc: "Connect port gpio from port group gpio61 to this pad." }
                      { value: "2", name: "port_gpio62_gpio", desc: "Connect port gpio from port group gpio62 to this pad." }
                      { value: "3", name: "port_sdio1_sdio_clk", desc: "Connect port sdio_clk from port group sdio1 to this pad." }
                      { value: "4", name: "port_sdio1_sdio_cmd", desc: "Connect port sdio_cmd from port group sdio1 to this pad." }
                      { value: "5", name: "port_sdio1_sdio_data0", desc: "Connect port sdio_data0 from port group sdio1 to this pad." }
                      { value: "6", name: "port_sdio1_sdio_data1", desc: "Connect port sdio_data1 from port group sdio1 to this pad." }
                      { value: "7", name: "port_sdio1_sdio_data2", desc: "Connect port sdio_data2 from port group sdio1 to this pad." }
                      { value: "8", name: "port_sdio1_sdio_data3", desc: "Connect port sdio_data3 from port group sdio1 to this pad." }
                      { value: "9", name: "port_uart5_uart_cts", desc: "Connect port uart_cts from port group uart5 to this pad." }
                      { value: "10", name: "port_uart5_uart_rts", desc: "Connect port uart_rts from port group uart5 to this pad." }
                      { value: "11", name: "port_uart5_uart_rx", desc: "Connect port uart_rx from port group uart5 to this pad." }
                      { value: "12", name: "port_uart5_uart_tx", desc: "Connect port uart_tx from port group uart5 to this pad." }
                      { value: "13", name: "port_uart6_uart_rx", desc: "Connect port uart_rx from port group uart6 to this pad." }
                      { value: "14", name: "port_uart6_uart_tx", desc: "Connect port uart_tx from port group uart6 to this pad." }
                  ]
              }
          ]
      }

      {
          name: PAD_MX_SDIO1_1_CFG
          desc: '''
            Pad signal configuration.
          '''
          swaccess: "rw"
          fields: [
            {
                bits: "0"
                name: chip2pad
                desc: '''
                     The signal that connects to the pads TX driver
                '''
                swaccess: "rw"
                hwaccess: "hro"
                resval: "0"
            },
            {
                bits: "1"
                name: oen
                desc: '''
                     Output enable signal, active low
                '''
                swaccess: "rw"
                hwaccess: "hro"
                resval: "1"
            },
          ]
      }

       {
          name: PAD_MX_SDIO1_1_MUX_SEL
          desc: '''
              Pad signal port multiplex selection for pad pad_mx_sdio1_1. The programmed value defines which port
              is connected to the pad.
          '''
          swaccess: "rw"
          hwaccess: "hro"
          resval: 0
          fields: [
              {
                  bits: "3:0"
                  enum: [
                      { value: "0", name: "register", desc: "Connects the Pad to the internal configuration register."}
                      { value: "1", name: "port_gpio61_gpio", desc: "Connect port gpio from port group gpio61 to this pad." }
                      { value: "2", name: "port_gpio62_gpio", desc: "Connect port gpio from port group gpio62 to this pad." }
                      { value: "3", name: "port_sdio1_sdio_clk", desc: "Connect port sdio_clk from port group sdio1 to this pad." }
                      { value: "4", name: "port_sdio1_sdio_cmd", desc: "Connect port sdio_cmd from port group sdio1 to this pad." }
                      { value: "5", name: "port_sdio1_sdio_data0", desc: "Connect port sdio_data0 from port group sdio1 to this pad." }
                      { value: "6", name: "port_sdio1_sdio_data1", desc: "Connect port sdio_data1 from port group sdio1 to this pad." }
                      { value: "7", name: "port_sdio1_sdio_data2", desc: "Connect port sdio_data2 from port group sdio1 to this pad." }
                      { value: "8", name: "port_sdio1_sdio_data3", desc: "Connect port sdio_data3 from port group sdio1 to this pad." }
                      { value: "9", name: "port_uart5_uart_cts", desc: "Connect port uart_cts from port group uart5 to this pad." }
                      { value: "10", name: "port_uart5_uart_rts", desc: "Connect port uart_rts from port group uart5 to this pad." }
                      { value: "11", name: "port_uart5_uart_rx", desc: "Connect port uart_rx from port group uart5 to this pad." }
                      { value: "12", name: "port_uart5_uart_tx", desc: "Connect port uart_tx from port group uart5 to this pad." }
                      { value: "13", name: "port_uart6_uart_rx", desc: "Connect port uart_rx from port group uart6 to this pad." }
                      { value: "14", name: "port_uart6_uart_tx", desc: "Connect port uart_tx from port group uart6 to this pad." }
                  ]
              }
          ]
      }

      {
          name: PAD_MX_SDIO1_2_CFG
          desc: '''
            Pad signal configuration.
          '''
          swaccess: "rw"
          fields: [
            {
                bits: "0"
                name: chip2pad
                desc: '''
                     The signal that connects to the pads TX driver
                '''
                swaccess: "rw"
                hwaccess: "hro"
                resval: "0"
            },
            {
                bits: "1"
                name: oen
                desc: '''
                     Output enable signal, active low
                '''
                swaccess: "rw"
                hwaccess: "hro"
                resval: "1"
            },
          ]
      }

       {
          name: PAD_MX_SDIO1_2_MUX_SEL
          desc: '''
              Pad signal port multiplex selection for pad pad_mx_sdio1_2. The programmed value defines which port
              is connected to the pad.
          '''
          swaccess: "rw"
          hwaccess: "hro"
          resval: 0
          fields: [
              {
                  bits: "3:0"
                  enum: [
                      { value: "0", name: "register", desc: "Connects the Pad to the internal configuration register."}
                      { value: "1", name: "port_gpio61_gpio", desc: "Connect port gpio from port group gpio61 to this pad." }
                      { value: "2", name: "port_gpio62_gpio", desc: "Connect port gpio from port group gpio62 to this pad." }
                      { value: "3", name: "port_sdio1_sdio_clk", desc: "Connect port sdio_clk from port group sdio1 to this pad." }
                      { value: "4", name: "port_sdio1_sdio_cmd", desc: "Connect port sdio_cmd from port group sdio1 to this pad." }
                      { value: "5", name: "port_sdio1_sdio_data0", desc: "Connect port sdio_data0 from port group sdio1 to this pad." }
                      { value: "6", name: "port_sdio1_sdio_data1", desc: "Connect port sdio_data1 from port group sdio1 to this pad." }
                      { value: "7", name: "port_sdio1_sdio_data2", desc: "Connect port sdio_data2 from port group sdio1 to this pad." }
                      { value: "8", name: "port_sdio1_sdio_data3", desc: "Connect port sdio_data3 from port group sdio1 to this pad." }
                      { value: "9", name: "port_uart5_uart_cts", desc: "Connect port uart_cts from port group uart5 to this pad." }
                      { value: "10", name: "port_uart5_uart_rts", desc: "Connect port uart_rts from port group uart5 to this pad." }
                      { value: "11", name: "port_uart5_uart_rx", desc: "Connect port uart_rx from port group uart5 to this pad." }
                      { value: "12", name: "port_uart5_uart_tx", desc: "Connect port uart_tx from port group uart5 to this pad." }
                      { value: "13", name: "port_uart6_uart_rx", desc: "Connect port uart_rx from port group uart6 to this pad." }
                      { value: "14", name: "port_uart6_uart_tx", desc: "Connect port uart_tx from port group uart6 to this pad." }
                  ]
              }
          ]
      }

      {
          name: PAD_MX_SDIO1_3_CFG
          desc: '''
            Pad signal configuration.
          '''
          swaccess: "rw"
          fields: [
            {
                bits: "0"
                name: chip2pad
                desc: '''
                     The signal that connects to the pads TX driver
                '''
                swaccess: "rw"
                hwaccess: "hro"
                resval: "0"
            },
            {
                bits: "1"
                name: oen
                desc: '''
                     Output enable signal, active low
                '''
                swaccess: "rw"
                hwaccess: "hro"
                resval: "1"
            },
          ]
      }

       {
          name: PAD_MX_SDIO1_3_MUX_SEL
          desc: '''
              Pad signal port multiplex selection for pad pad_mx_sdio1_3. The programmed value defines which port
              is connected to the pad.
          '''
          swaccess: "rw"
          hwaccess: "hro"
          resval: 0
          fields: [
              {
                  bits: "3:0"
                  enum: [
                      { value: "0", name: "register", desc: "Connects the Pad to the internal configuration register."}
                      { value: "1", name: "port_gpio61_gpio", desc: "Connect port gpio from port group gpio61 to this pad." }
                      { value: "2", name: "port_gpio62_gpio", desc: "Connect port gpio from port group gpio62 to this pad." }
                      { value: "3", name: "port_sdio1_sdio_clk", desc: "Connect port sdio_clk from port group sdio1 to this pad." }
                      { value: "4", name: "port_sdio1_sdio_cmd", desc: "Connect port sdio_cmd from port group sdio1 to this pad." }
                      { value: "5", name: "port_sdio1_sdio_data0", desc: "Connect port sdio_data0 from port group sdio1 to this pad." }
                      { value: "6", name: "port_sdio1_sdio_data1", desc: "Connect port sdio_data1 from port group sdio1 to this pad." }
                      { value: "7", name: "port_sdio1_sdio_data2", desc: "Connect port sdio_data2 from port group sdio1 to this pad." }
                      { value: "8", name: "port_sdio1_sdio_data3", desc: "Connect port sdio_data3 from port group sdio1 to this pad." }
                      { value: "9", name: "port_uart5_uart_cts", desc: "Connect port uart_cts from port group uart5 to this pad." }
                      { value: "10", name: "port_uart5_uart_rts", desc: "Connect port uart_rts from port group uart5 to this pad." }
                      { value: "11", name: "port_uart5_uart_rx", desc: "Connect port uart_rx from port group uart5 to this pad." }
                      { value: "12", name: "port_uart5_uart_tx", desc: "Connect port uart_tx from port group uart5 to this pad." }
                      { value: "13", name: "port_uart6_uart_rx", desc: "Connect port uart_rx from port group uart6 to this pad." }
                      { value: "14", name: "port_uart6_uart_tx", desc: "Connect port uart_tx from port group uart6 to this pad." }
                  ]
              }
          ]
      }

      {
          name: PAD_MX_SDIO1_4_CFG
          desc: '''
            Pad signal configuration.
          '''
          swaccess: "rw"
          fields: [
            {
                bits: "0"
                name: chip2pad
                desc: '''
                     The signal that connects to the pads TX driver
                '''
                swaccess: "rw"
                hwaccess: "hro"
                resval: "0"
            },
            {
                bits: "1"
                name: oen
                desc: '''
                     Output enable signal, active low
                '''
                swaccess: "rw"
                hwaccess: "hro"
                resval: "1"
            },
          ]
      }

       {
          name: PAD_MX_SDIO1_4_MUX_SEL
          desc: '''
              Pad signal port multiplex selection for pad pad_mx_sdio1_4. The programmed value defines which port
              is connected to the pad.
          '''
          swaccess: "rw"
          hwaccess: "hro"
          resval: 0
          fields: [
              {
                  bits: "3:0"
                  enum: [
                      { value: "0", name: "register", desc: "Connects the Pad to the internal configuration register."}
                      { value: "1", name: "port_gpio61_gpio", desc: "Connect port gpio from port group gpio61 to this pad." }
                      { value: "2", name: "port_gpio62_gpio", desc: "Connect port gpio from port group gpio62 to this pad." }
                      { value: "3", name: "port_sdio1_sdio_clk", desc: "Connect port sdio_clk from port group sdio1 to this pad." }
                      { value: "4", name: "port_sdio1_sdio_cmd", desc: "Connect port sdio_cmd from port group sdio1 to this pad." }
                      { value: "5", name: "port_sdio1_sdio_data0", desc: "Connect port sdio_data0 from port group sdio1 to this pad." }
                      { value: "6", name: "port_sdio1_sdio_data1", desc: "Connect port sdio_data1 from port group sdio1 to this pad." }
                      { value: "7", name: "port_sdio1_sdio_data2", desc: "Connect port sdio_data2 from port group sdio1 to this pad." }
                      { value: "8", name: "port_sdio1_sdio_data3", desc: "Connect port sdio_data3 from port group sdio1 to this pad." }
                      { value: "9", name: "port_uart5_uart_cts", desc: "Connect port uart_cts from port group uart5 to this pad." }
                      { value: "10", name: "port_uart5_uart_rts", desc: "Connect port uart_rts from port group uart5 to this pad." }
                      { value: "11", name: "port_uart5_uart_rx", desc: "Connect port uart_rx from port group uart5 to this pad." }
                      { value: "12", name: "port_uart5_uart_tx", desc: "Connect port uart_tx from port group uart5 to this pad." }
                      { value: "13", name: "port_uart6_uart_rx", desc: "Connect port uart_rx from port group uart6 to this pad." }
                      { value: "14", name: "port_uart6_uart_tx", desc: "Connect port uart_tx from port group uart6 to this pad." }
                  ]
              }
          ]
      }

      {
          name: PAD_MX_SDIO1_5_CFG
          desc: '''
            Pad signal configuration.
          '''
          swaccess: "rw"
          fields: [
            {
                bits: "0"
                name: chip2pad
                desc: '''
                     The signal that connects to the pads TX driver
                '''
                swaccess: "rw"
                hwaccess: "hro"
                resval: "0"
            },
            {
                bits: "1"
                name: oen
                desc: '''
                     Output enable signal, active low
                '''
                swaccess: "rw"
                hwaccess: "hro"
                resval: "1"
            },
          ]
      }

       {
          name: PAD_MX_SDIO1_5_MUX_SEL
          desc: '''
              Pad signal port multiplex selection for pad pad_mx_sdio1_5. The programmed value defines which port
              is connected to the pad.
          '''
          swaccess: "rw"
          hwaccess: "hro"
          resval: 0
          fields: [
              {
                  bits: "3:0"
                  enum: [
                      { value: "0", name: "register", desc: "Connects the Pad to the internal configuration register."}
                      { value: "1", name: "port_gpio61_gpio", desc: "Connect port gpio from port group gpio61 to this pad." }
                      { value: "2", name: "port_gpio62_gpio", desc: "Connect port gpio from port group gpio62 to this pad." }
                      { value: "3", name: "port_sdio1_sdio_clk", desc: "Connect port sdio_clk from port group sdio1 to this pad." }
                      { value: "4", name: "port_sdio1_sdio_cmd", desc: "Connect port sdio_cmd from port group sdio1 to this pad." }
                      { value: "5", name: "port_sdio1_sdio_data0", desc: "Connect port sdio_data0 from port group sdio1 to this pad." }
                      { value: "6", name: "port_sdio1_sdio_data1", desc: "Connect port sdio_data1 from port group sdio1 to this pad." }
                      { value: "7", name: "port_sdio1_sdio_data2", desc: "Connect port sdio_data2 from port group sdio1 to this pad." }
                      { value: "8", name: "port_sdio1_sdio_data3", desc: "Connect port sdio_data3 from port group sdio1 to this pad." }
                      { value: "9", name: "port_uart5_uart_cts", desc: "Connect port uart_cts from port group uart5 to this pad." }
                      { value: "10", name: "port_uart5_uart_rts", desc: "Connect port uart_rts from port group uart5 to this pad." }
                      { value: "11", name: "port_uart5_uart_rx", desc: "Connect port uart_rx from port group uart5 to this pad." }
                      { value: "12", name: "port_uart5_uart_tx", desc: "Connect port uart_tx from port group uart5 to this pad." }
                      { value: "13", name: "port_uart6_uart_rx", desc: "Connect port uart_rx from port group uart6 to this pad." }
                      { value: "14", name: "port_uart6_uart_tx", desc: "Connect port uart_tx from port group uart6 to this pad." }
                  ]
              }
          ]
      }

      {
          name: PAD_MX_SDIO1_6_CFG
          desc: '''
            Pad signal configuration.
          '''
          swaccess: "rw"
          fields: [
            {
                bits: "0"
                name: chip2pad
                desc: '''
                     The signal that connects to the pads TX driver
                '''
                swaccess: "rw"
                hwaccess: "hro"
                resval: "0"
            },
            {
                bits: "1"
                name: oen
                desc: '''
                     Output enable signal, active low
                '''
                swaccess: "rw"
                hwaccess: "hro"
                resval: "1"
            },
          ]
      }

       {
          name: PAD_MX_SDIO1_6_MUX_SEL
          desc: '''
              Pad signal port multiplex selection for pad pad_mx_sdio1_6. The programmed value defines which port
              is connected to the pad.
          '''
          swaccess: "rw"
          hwaccess: "hro"
          resval: 0
          fields: [
              {
                  bits: "3:0"
                  enum: [
                      { value: "0", name: "register", desc: "Connects the Pad to the internal configuration register."}
                      { value: "1", name: "port_gpio61_gpio", desc: "Connect port gpio from port group gpio61 to this pad." }
                      { value: "2", name: "port_gpio62_gpio", desc: "Connect port gpio from port group gpio62 to this pad." }
                      { value: "3", name: "port_sdio1_sdio_clk", desc: "Connect port sdio_clk from port group sdio1 to this pad." }
                      { value: "4", name: "port_sdio1_sdio_cmd", desc: "Connect port sdio_cmd from port group sdio1 to this pad." }
                      { value: "5", name: "port_sdio1_sdio_data0", desc: "Connect port sdio_data0 from port group sdio1 to this pad." }
                      { value: "6", name: "port_sdio1_sdio_data1", desc: "Connect port sdio_data1 from port group sdio1 to this pad." }
                      { value: "7", name: "port_sdio1_sdio_data2", desc: "Connect port sdio_data2 from port group sdio1 to this pad." }
                      { value: "8", name: "port_sdio1_sdio_data3", desc: "Connect port sdio_data3 from port group sdio1 to this pad." }
                      { value: "9", name: "port_uart5_uart_cts", desc: "Connect port uart_cts from port group uart5 to this pad." }
                      { value: "10", name: "port_uart5_uart_rts", desc: "Connect port uart_rts from port group uart5 to this pad." }
                      { value: "11", name: "port_uart5_uart_rx", desc: "Connect port uart_rx from port group uart5 to this pad." }
                      { value: "12", name: "port_uart5_uart_tx", desc: "Connect port uart_tx from port group uart5 to this pad." }
                      { value: "13", name: "port_uart6_uart_rx", desc: "Connect port uart_rx from port group uart6 to this pad." }
                      { value: "14", name: "port_uart6_uart_tx", desc: "Connect port uart_tx from port group uart6 to this pad." }
                  ]
              }
          ]
      }

      {
          name: PAD_MX_SDIO1_7_CFG
          desc: '''
            Pad signal configuration.
          '''
          swaccess: "rw"
          fields: [
            {
                bits: "0"
                name: chip2pad
                desc: '''
                     The signal that connects to the pads TX driver
                '''
                swaccess: "rw"
                hwaccess: "hro"
                resval: "0"
            },
            {
                bits: "1"
                name: oen
                desc: '''
                     Output enable signal, active low
                '''
                swaccess: "rw"
                hwaccess: "hro"
                resval: "1"
            },
          ]
      }

       {
          name: PAD_MX_SDIO1_7_MUX_SEL
          desc: '''
              Pad signal port multiplex selection for pad pad_mx_sdio1_7. The programmed value defines which port
              is connected to the pad.
          '''
          swaccess: "rw"
          hwaccess: "hro"
          resval: 0
          fields: [
              {
                  bits: "3:0"
                  enum: [
                      { value: "0", name: "register", desc: "Connects the Pad to the internal configuration register."}
                      { value: "1", name: "port_gpio61_gpio", desc: "Connect port gpio from port group gpio61 to this pad." }
                      { value: "2", name: "port_gpio62_gpio", desc: "Connect port gpio from port group gpio62 to this pad." }
                      { value: "3", name: "port_sdio1_sdio_clk", desc: "Connect port sdio_clk from port group sdio1 to this pad." }
                      { value: "4", name: "port_sdio1_sdio_cmd", desc: "Connect port sdio_cmd from port group sdio1 to this pad." }
                      { value: "5", name: "port_sdio1_sdio_data0", desc: "Connect port sdio_data0 from port group sdio1 to this pad." }
                      { value: "6", name: "port_sdio1_sdio_data1", desc: "Connect port sdio_data1 from port group sdio1 to this pad." }
                      { value: "7", name: "port_sdio1_sdio_data2", desc: "Connect port sdio_data2 from port group sdio1 to this pad." }
                      { value: "8", name: "port_sdio1_sdio_data3", desc: "Connect port sdio_data3 from port group sdio1 to this pad." }
                      { value: "9", name: "port_uart5_uart_cts", desc: "Connect port uart_cts from port group uart5 to this pad." }
                      { value: "10", name: "port_uart5_uart_rts", desc: "Connect port uart_rts from port group uart5 to this pad." }
                      { value: "11", name: "port_uart5_uart_rx", desc: "Connect port uart_rx from port group uart5 to this pad." }
                      { value: "12", name: "port_uart5_uart_tx", desc: "Connect port uart_tx from port group uart5 to this pad." }
                      { value: "13", name: "port_uart6_uart_rx", desc: "Connect port uart_rx from port group uart6 to this pad." }
                      { value: "14", name: "port_uart6_uart_tx", desc: "Connect port uart_tx from port group uart6 to this pad." }
                  ]
              }
          ]
      }

      {
          name: PAD_MX_HYPER1_0_CFG
          desc: '''
            Pad signal configuration.
          '''
          swaccess: "rw"
          fields: [
            {
                bits: "0"
                name: chip2pad
                desc: '''
                     The signal that connects to the pads TX driver
                '''
                swaccess: "rw"
                hwaccess: "hro"
                resval: "0"
            },
            {
                bits: "1"
                name: oen
                desc: '''
                     Output enable signal, active low
                '''
                swaccess: "rw"
                hwaccess: "hro"
                resval: "1"
            },
          ]
      }

       {
          name: PAD_MX_HYPER1_0_MUX_SEL
          desc: '''
              Pad signal port multiplex selection for pad pad_mx_hyper1_0. The programmed value defines which port
              is connected to the pad.
          '''
          swaccess: "rw"
          hwaccess: "hro"
          resval: 0
          fields: [
              {
                  bits: "4:0"
                  enum: [
                      { value: "0", name: "register", desc: "Connects the Pad to the internal configuration register."}
                      { value: "1", name: "port_eth0_eth_rst", desc: "Connect port eth_rst from port group eth0 to this pad." }
                      { value: "2", name: "port_eth0_eth_rxck", desc: "Connect port eth_rxck from port group eth0 to this pad." }
                      { value: "3", name: "port_eth0_eth_rxctl", desc: "Connect port eth_rxctl from port group eth0 to this pad." }
                      { value: "4", name: "port_eth0_eth_rxd0", desc: "Connect port eth_rxd0 from port group eth0 to this pad." }
                      { value: "5", name: "port_eth0_eth_rxd1", desc: "Connect port eth_rxd1 from port group eth0 to this pad." }
                      { value: "6", name: "port_eth0_eth_rxd2", desc: "Connect port eth_rxd2 from port group eth0 to this pad." }
                      { value: "7", name: "port_eth0_eth_rxd3", desc: "Connect port eth_rxd3 from port group eth0 to this pad." }
                      { value: "8", name: "port_eth0_eth_txck", desc: "Connect port eth_txck from port group eth0 to this pad." }
                      { value: "9", name: "port_eth0_eth_txctl", desc: "Connect port eth_txctl from port group eth0 to this pad." }
                      { value: "10", name: "port_eth0_eth_txd0", desc: "Connect port eth_txd0 from port group eth0 to this pad." }
                      { value: "11", name: "port_eth0_eth_txd1", desc: "Connect port eth_txd1 from port group eth0 to this pad." }
                      { value: "12", name: "port_eth0_eth_txd2", desc: "Connect port eth_txd2 from port group eth0 to this pad." }
                      { value: "13", name: "port_eth0_eth_txd3", desc: "Connect port eth_txd3 from port group eth0 to this pad." }
                      { value: "14", name: "port_hyper1_hyper_ck", desc: "Connect port hyper_ck from port group hyper1 to this pad." }
                      { value: "15", name: "port_hyper1_hyper_ckn", desc: "Connect port hyper_ckn from port group hyper1 to this pad." }
                      { value: "16", name: "port_hyper1_hyper_cs0", desc: "Connect port hyper_cs0 from port group hyper1 to this pad." }
                      { value: "17", name: "port_hyper1_hyper_cs1", desc: "Connect port hyper_cs1 from port group hyper1 to this pad." }
                      { value: "18", name: "port_hyper1_hyper_dq0_i", desc: "Connect port hyper_dq0_i from port group hyper1 to this pad." }
                      { value: "19", name: "port_hyper1_hyper_rst", desc: "Connect port hyper_rst from port group hyper1 to this pad." }
                      { value: "20", name: "port_hyper1_hyper_rwds", desc: "Connect port hyper_rwds from port group hyper1 to this pad." }
                      { value: "21", name: "port_i2c5_i2c_scl", desc: "Connect port i2c_scl from port group i2c5 to this pad." }
                      { value: "22", name: "port_i2c5_i2c_sda", desc: "Connect port i2c_sda from port group i2c5 to this pad." }
                      { value: "23", name: "port_uart7_uart_rx", desc: "Connect port uart_rx from port group uart7 to this pad." }
                      { value: "24", name: "port_uart7_uart_tx", desc: "Connect port uart_tx from port group uart7 to this pad." }
                  ]
              }
          ]
      }

      {
          name: PAD_MX_HYPER1_1_CFG
          desc: '''
            Pad signal configuration.
          '''
          swaccess: "rw"
          fields: [
            {
                bits: "0"
                name: chip2pad
                desc: '''
                     The signal that connects to the pads TX driver
                '''
                swaccess: "rw"
                hwaccess: "hro"
                resval: "0"
            },
            {
                bits: "1"
                name: oen
                desc: '''
                     Output enable signal, active low
                '''
                swaccess: "rw"
                hwaccess: "hro"
                resval: "1"
            },
          ]
      }

       {
          name: PAD_MX_HYPER1_1_MUX_SEL
          desc: '''
              Pad signal port multiplex selection for pad pad_mx_hyper1_1. The programmed value defines which port
              is connected to the pad.
          '''
          swaccess: "rw"
          hwaccess: "hro"
          resval: 0
          fields: [
              {
                  bits: "4:0"
                  enum: [
                      { value: "0", name: "register", desc: "Connects the Pad to the internal configuration register."}
                      { value: "1", name: "port_eth0_eth_rst", desc: "Connect port eth_rst from port group eth0 to this pad." }
                      { value: "2", name: "port_eth0_eth_rxck", desc: "Connect port eth_rxck from port group eth0 to this pad." }
                      { value: "3", name: "port_eth0_eth_rxctl", desc: "Connect port eth_rxctl from port group eth0 to this pad." }
                      { value: "4", name: "port_eth0_eth_rxd0", desc: "Connect port eth_rxd0 from port group eth0 to this pad." }
                      { value: "5", name: "port_eth0_eth_rxd1", desc: "Connect port eth_rxd1 from port group eth0 to this pad." }
                      { value: "6", name: "port_eth0_eth_rxd2", desc: "Connect port eth_rxd2 from port group eth0 to this pad." }
                      { value: "7", name: "port_eth0_eth_rxd3", desc: "Connect port eth_rxd3 from port group eth0 to this pad." }
                      { value: "8", name: "port_eth0_eth_txck", desc: "Connect port eth_txck from port group eth0 to this pad." }
                      { value: "9", name: "port_eth0_eth_txctl", desc: "Connect port eth_txctl from port group eth0 to this pad." }
                      { value: "10", name: "port_eth0_eth_txd0", desc: "Connect port eth_txd0 from port group eth0 to this pad." }
                      { value: "11", name: "port_eth0_eth_txd1", desc: "Connect port eth_txd1 from port group eth0 to this pad." }
                      { value: "12", name: "port_eth0_eth_txd2", desc: "Connect port eth_txd2 from port group eth0 to this pad." }
                      { value: "13", name: "port_eth0_eth_txd3", desc: "Connect port eth_txd3 from port group eth0 to this pad." }
                      { value: "14", name: "port_hyper1_hyper_ck", desc: "Connect port hyper_ck from port group hyper1 to this pad." }
                      { value: "15", name: "port_hyper1_hyper_ckn", desc: "Connect port hyper_ckn from port group hyper1 to this pad." }
                      { value: "16", name: "port_hyper1_hyper_cs0", desc: "Connect port hyper_cs0 from port group hyper1 to this pad." }
                      { value: "17", name: "port_hyper1_hyper_cs1", desc: "Connect port hyper_cs1 from port group hyper1 to this pad." }
                      { value: "18", name: "port_hyper1_hyper_dq0_i", desc: "Connect port hyper_dq0_i from port group hyper1 to this pad." }
                      { value: "19", name: "port_hyper1_hyper_rst", desc: "Connect port hyper_rst from port group hyper1 to this pad." }
                      { value: "20", name: "port_hyper1_hyper_rwds", desc: "Connect port hyper_rwds from port group hyper1 to this pad." }
                      { value: "21", name: "port_i2c5_i2c_scl", desc: "Connect port i2c_scl from port group i2c5 to this pad." }
                      { value: "22", name: "port_i2c5_i2c_sda", desc: "Connect port i2c_sda from port group i2c5 to this pad." }
                      { value: "23", name: "port_uart7_uart_rx", desc: "Connect port uart_rx from port group uart7 to this pad." }
                      { value: "24", name: "port_uart7_uart_tx", desc: "Connect port uart_tx from port group uart7 to this pad." }
                  ]
              }
          ]
      }

      {
          name: PAD_MX_HYPER1_2_CFG
          desc: '''
            Pad signal configuration.
          '''
          swaccess: "rw"
          fields: [
            {
                bits: "0"
                name: chip2pad
                desc: '''
                     The signal that connects to the pads TX driver
                '''
                swaccess: "rw"
                hwaccess: "hro"
                resval: "0"
            },
            {
                bits: "1"
                name: oen
                desc: '''
                     Output enable signal, active low
                '''
                swaccess: "rw"
                hwaccess: "hro"
                resval: "1"
            },
          ]
      }

       {
          name: PAD_MX_HYPER1_2_MUX_SEL
          desc: '''
              Pad signal port multiplex selection for pad pad_mx_hyper1_2. The programmed value defines which port
              is connected to the pad.
          '''
          swaccess: "rw"
          hwaccess: "hro"
          resval: 0
          fields: [
              {
                  bits: "4:0"
                  enum: [
                      { value: "0", name: "register", desc: "Connects the Pad to the internal configuration register."}
                      { value: "1", name: "port_eth0_eth_rst", desc: "Connect port eth_rst from port group eth0 to this pad." }
                      { value: "2", name: "port_eth0_eth_rxck", desc: "Connect port eth_rxck from port group eth0 to this pad." }
                      { value: "3", name: "port_eth0_eth_rxctl", desc: "Connect port eth_rxctl from port group eth0 to this pad." }
                      { value: "4", name: "port_eth0_eth_rxd0", desc: "Connect port eth_rxd0 from port group eth0 to this pad." }
                      { value: "5", name: "port_eth0_eth_rxd1", desc: "Connect port eth_rxd1 from port group eth0 to this pad." }
                      { value: "6", name: "port_eth0_eth_rxd2", desc: "Connect port eth_rxd2 from port group eth0 to this pad." }
                      { value: "7", name: "port_eth0_eth_rxd3", desc: "Connect port eth_rxd3 from port group eth0 to this pad." }
                      { value: "8", name: "port_eth0_eth_txck", desc: "Connect port eth_txck from port group eth0 to this pad." }
                      { value: "9", name: "port_eth0_eth_txctl", desc: "Connect port eth_txctl from port group eth0 to this pad." }
                      { value: "10", name: "port_eth0_eth_txd0", desc: "Connect port eth_txd0 from port group eth0 to this pad." }
                      { value: "11", name: "port_eth0_eth_txd1", desc: "Connect port eth_txd1 from port group eth0 to this pad." }
                      { value: "12", name: "port_eth0_eth_txd2", desc: "Connect port eth_txd2 from port group eth0 to this pad." }
                      { value: "13", name: "port_eth0_eth_txd3", desc: "Connect port eth_txd3 from port group eth0 to this pad." }
                      { value: "14", name: "port_hyper1_hyper_ck", desc: "Connect port hyper_ck from port group hyper1 to this pad." }
                      { value: "15", name: "port_hyper1_hyper_ckn", desc: "Connect port hyper_ckn from port group hyper1 to this pad." }
                      { value: "16", name: "port_hyper1_hyper_cs0", desc: "Connect port hyper_cs0 from port group hyper1 to this pad." }
                      { value: "17", name: "port_hyper1_hyper_cs1", desc: "Connect port hyper_cs1 from port group hyper1 to this pad." }
                      { value: "18", name: "port_hyper1_hyper_dq0_i", desc: "Connect port hyper_dq0_i from port group hyper1 to this pad." }
                      { value: "19", name: "port_hyper1_hyper_rst", desc: "Connect port hyper_rst from port group hyper1 to this pad." }
                      { value: "20", name: "port_hyper1_hyper_rwds", desc: "Connect port hyper_rwds from port group hyper1 to this pad." }
                      { value: "21", name: "port_i2c5_i2c_scl", desc: "Connect port i2c_scl from port group i2c5 to this pad." }
                      { value: "22", name: "port_i2c5_i2c_sda", desc: "Connect port i2c_sda from port group i2c5 to this pad." }
                      { value: "23", name: "port_uart7_uart_rx", desc: "Connect port uart_rx from port group uart7 to this pad." }
                      { value: "24", name: "port_uart7_uart_tx", desc: "Connect port uart_tx from port group uart7 to this pad." }
                  ]
              }
          ]
      }

      {
          name: PAD_MX_HYPER1_3_CFG
          desc: '''
            Pad signal configuration.
          '''
          swaccess: "rw"
          fields: [
            {
                bits: "0"
                name: chip2pad
                desc: '''
                     The signal that connects to the pads TX driver
                '''
                swaccess: "rw"
                hwaccess: "hro"
                resval: "0"
            },
            {
                bits: "1"
                name: oen
                desc: '''
                     Output enable signal, active low
                '''
                swaccess: "rw"
                hwaccess: "hro"
                resval: "1"
            },
          ]
      }

       {
          name: PAD_MX_HYPER1_3_MUX_SEL
          desc: '''
              Pad signal port multiplex selection for pad pad_mx_hyper1_3. The programmed value defines which port
              is connected to the pad.
          '''
          swaccess: "rw"
          hwaccess: "hro"
          resval: 0
          fields: [
              {
                  bits: "4:0"
                  enum: [
                      { value: "0", name: "register", desc: "Connects the Pad to the internal configuration register."}
                      { value: "1", name: "port_eth0_eth_rst", desc: "Connect port eth_rst from port group eth0 to this pad." }
                      { value: "2", name: "port_eth0_eth_rxck", desc: "Connect port eth_rxck from port group eth0 to this pad." }
                      { value: "3", name: "port_eth0_eth_rxctl", desc: "Connect port eth_rxctl from port group eth0 to this pad." }
                      { value: "4", name: "port_eth0_eth_rxd0", desc: "Connect port eth_rxd0 from port group eth0 to this pad." }
                      { value: "5", name: "port_eth0_eth_rxd1", desc: "Connect port eth_rxd1 from port group eth0 to this pad." }
                      { value: "6", name: "port_eth0_eth_rxd2", desc: "Connect port eth_rxd2 from port group eth0 to this pad." }
                      { value: "7", name: "port_eth0_eth_rxd3", desc: "Connect port eth_rxd3 from port group eth0 to this pad." }
                      { value: "8", name: "port_eth0_eth_txck", desc: "Connect port eth_txck from port group eth0 to this pad." }
                      { value: "9", name: "port_eth0_eth_txctl", desc: "Connect port eth_txctl from port group eth0 to this pad." }
                      { value: "10", name: "port_eth0_eth_txd0", desc: "Connect port eth_txd0 from port group eth0 to this pad." }
                      { value: "11", name: "port_eth0_eth_txd1", desc: "Connect port eth_txd1 from port group eth0 to this pad." }
                      { value: "12", name: "port_eth0_eth_txd2", desc: "Connect port eth_txd2 from port group eth0 to this pad." }
                      { value: "13", name: "port_eth0_eth_txd3", desc: "Connect port eth_txd3 from port group eth0 to this pad." }
                      { value: "14", name: "port_hyper1_hyper_ck", desc: "Connect port hyper_ck from port group hyper1 to this pad." }
                      { value: "15", name: "port_hyper1_hyper_ckn", desc: "Connect port hyper_ckn from port group hyper1 to this pad." }
                      { value: "16", name: "port_hyper1_hyper_cs0", desc: "Connect port hyper_cs0 from port group hyper1 to this pad." }
                      { value: "17", name: "port_hyper1_hyper_cs1", desc: "Connect port hyper_cs1 from port group hyper1 to this pad." }
                      { value: "18", name: "port_hyper1_hyper_dq0_i", desc: "Connect port hyper_dq0_i from port group hyper1 to this pad." }
                      { value: "19", name: "port_hyper1_hyper_rst", desc: "Connect port hyper_rst from port group hyper1 to this pad." }
                      { value: "20", name: "port_hyper1_hyper_rwds", desc: "Connect port hyper_rwds from port group hyper1 to this pad." }
                      { value: "21", name: "port_i2c5_i2c_scl", desc: "Connect port i2c_scl from port group i2c5 to this pad." }
                      { value: "22", name: "port_i2c5_i2c_sda", desc: "Connect port i2c_sda from port group i2c5 to this pad." }
                      { value: "23", name: "port_uart7_uart_rx", desc: "Connect port uart_rx from port group uart7 to this pad." }
                      { value: "24", name: "port_uart7_uart_tx", desc: "Connect port uart_tx from port group uart7 to this pad." }
                  ]
              }
          ]
      }

      {
          name: PAD_MX_HYPER1_4_CFG
          desc: '''
            Pad signal configuration.
          '''
          swaccess: "rw"
          fields: [
            {
                bits: "0"
                name: chip2pad
                desc: '''
                     The signal that connects to the pads TX driver
                '''
                swaccess: "rw"
                hwaccess: "hro"
                resval: "0"
            },
            {
                bits: "1"
                name: oen
                desc: '''
                     Output enable signal, active low
                '''
                swaccess: "rw"
                hwaccess: "hro"
                resval: "1"
            },
          ]
      }

       {
          name: PAD_MX_HYPER1_4_MUX_SEL
          desc: '''
              Pad signal port multiplex selection for pad pad_mx_hyper1_4. The programmed value defines which port
              is connected to the pad.
          '''
          swaccess: "rw"
          hwaccess: "hro"
          resval: 0
          fields: [
              {
                  bits: "4:0"
                  enum: [
                      { value: "0", name: "register", desc: "Connects the Pad to the internal configuration register."}
                      { value: "1", name: "port_eth0_eth_rst", desc: "Connect port eth_rst from port group eth0 to this pad." }
                      { value: "2", name: "port_eth0_eth_rxck", desc: "Connect port eth_rxck from port group eth0 to this pad." }
                      { value: "3", name: "port_eth0_eth_rxctl", desc: "Connect port eth_rxctl from port group eth0 to this pad." }
                      { value: "4", name: "port_eth0_eth_rxd0", desc: "Connect port eth_rxd0 from port group eth0 to this pad." }
                      { value: "5", name: "port_eth0_eth_rxd1", desc: "Connect port eth_rxd1 from port group eth0 to this pad." }
                      { value: "6", name: "port_eth0_eth_rxd2", desc: "Connect port eth_rxd2 from port group eth0 to this pad." }
                      { value: "7", name: "port_eth0_eth_rxd3", desc: "Connect port eth_rxd3 from port group eth0 to this pad." }
                      { value: "8", name: "port_eth0_eth_txck", desc: "Connect port eth_txck from port group eth0 to this pad." }
                      { value: "9", name: "port_eth0_eth_txctl", desc: "Connect port eth_txctl from port group eth0 to this pad." }
                      { value: "10", name: "port_eth0_eth_txd0", desc: "Connect port eth_txd0 from port group eth0 to this pad." }
                      { value: "11", name: "port_eth0_eth_txd1", desc: "Connect port eth_txd1 from port group eth0 to this pad." }
                      { value: "12", name: "port_eth0_eth_txd2", desc: "Connect port eth_txd2 from port group eth0 to this pad." }
                      { value: "13", name: "port_eth0_eth_txd3", desc: "Connect port eth_txd3 from port group eth0 to this pad." }
                      { value: "14", name: "port_hyper1_hyper_ck", desc: "Connect port hyper_ck from port group hyper1 to this pad." }
                      { value: "15", name: "port_hyper1_hyper_ckn", desc: "Connect port hyper_ckn from port group hyper1 to this pad." }
                      { value: "16", name: "port_hyper1_hyper_cs0", desc: "Connect port hyper_cs0 from port group hyper1 to this pad." }
                      { value: "17", name: "port_hyper1_hyper_cs1", desc: "Connect port hyper_cs1 from port group hyper1 to this pad." }
                      { value: "18", name: "port_hyper1_hyper_dq0_i", desc: "Connect port hyper_dq0_i from port group hyper1 to this pad." }
                      { value: "19", name: "port_hyper1_hyper_rst", desc: "Connect port hyper_rst from port group hyper1 to this pad." }
                      { value: "20", name: "port_hyper1_hyper_rwds", desc: "Connect port hyper_rwds from port group hyper1 to this pad." }
                      { value: "21", name: "port_i2c5_i2c_scl", desc: "Connect port i2c_scl from port group i2c5 to this pad." }
                      { value: "22", name: "port_i2c5_i2c_sda", desc: "Connect port i2c_sda from port group i2c5 to this pad." }
                      { value: "23", name: "port_uart7_uart_rx", desc: "Connect port uart_rx from port group uart7 to this pad." }
                      { value: "24", name: "port_uart7_uart_tx", desc: "Connect port uart_tx from port group uart7 to this pad." }
                  ]
              }
          ]
      }

      {
          name: PAD_MX_HYPER1_5_CFG
          desc: '''
            Pad signal configuration.
          '''
          swaccess: "rw"
          fields: [
            {
                bits: "0"
                name: chip2pad
                desc: '''
                     The signal that connects to the pads TX driver
                '''
                swaccess: "rw"
                hwaccess: "hro"
                resval: "0"
            },
            {
                bits: "1"
                name: oen
                desc: '''
                     Output enable signal, active low
                '''
                swaccess: "rw"
                hwaccess: "hro"
                resval: "1"
            },
          ]
      }

       {
          name: PAD_MX_HYPER1_5_MUX_SEL
          desc: '''
              Pad signal port multiplex selection for pad pad_mx_hyper1_5. The programmed value defines which port
              is connected to the pad.
          '''
          swaccess: "rw"
          hwaccess: "hro"
          resval: 0
          fields: [
              {
                  bits: "4:0"
                  enum: [
                      { value: "0", name: "register", desc: "Connects the Pad to the internal configuration register."}
                      { value: "1", name: "port_eth0_eth_rst", desc: "Connect port eth_rst from port group eth0 to this pad." }
                      { value: "2", name: "port_eth0_eth_rxck", desc: "Connect port eth_rxck from port group eth0 to this pad." }
                      { value: "3", name: "port_eth0_eth_rxctl", desc: "Connect port eth_rxctl from port group eth0 to this pad." }
                      { value: "4", name: "port_eth0_eth_rxd0", desc: "Connect port eth_rxd0 from port group eth0 to this pad." }
                      { value: "5", name: "port_eth0_eth_rxd1", desc: "Connect port eth_rxd1 from port group eth0 to this pad." }
                      { value: "6", name: "port_eth0_eth_rxd2", desc: "Connect port eth_rxd2 from port group eth0 to this pad." }
                      { value: "7", name: "port_eth0_eth_rxd3", desc: "Connect port eth_rxd3 from port group eth0 to this pad." }
                      { value: "8", name: "port_eth0_eth_txck", desc: "Connect port eth_txck from port group eth0 to this pad." }
                      { value: "9", name: "port_eth0_eth_txctl", desc: "Connect port eth_txctl from port group eth0 to this pad." }
                      { value: "10", name: "port_eth0_eth_txd0", desc: "Connect port eth_txd0 from port group eth0 to this pad." }
                      { value: "11", name: "port_eth0_eth_txd1", desc: "Connect port eth_txd1 from port group eth0 to this pad." }
                      { value: "12", name: "port_eth0_eth_txd2", desc: "Connect port eth_txd2 from port group eth0 to this pad." }
                      { value: "13", name: "port_eth0_eth_txd3", desc: "Connect port eth_txd3 from port group eth0 to this pad." }
                      { value: "14", name: "port_hyper1_hyper_ck", desc: "Connect port hyper_ck from port group hyper1 to this pad." }
                      { value: "15", name: "port_hyper1_hyper_ckn", desc: "Connect port hyper_ckn from port group hyper1 to this pad." }
                      { value: "16", name: "port_hyper1_hyper_cs0", desc: "Connect port hyper_cs0 from port group hyper1 to this pad." }
                      { value: "17", name: "port_hyper1_hyper_cs1", desc: "Connect port hyper_cs1 from port group hyper1 to this pad." }
                      { value: "18", name: "port_hyper1_hyper_dq0_i", desc: "Connect port hyper_dq0_i from port group hyper1 to this pad." }
                      { value: "19", name: "port_hyper1_hyper_rst", desc: "Connect port hyper_rst from port group hyper1 to this pad." }
                      { value: "20", name: "port_hyper1_hyper_rwds", desc: "Connect port hyper_rwds from port group hyper1 to this pad." }
                      { value: "21", name: "port_i2c5_i2c_scl", desc: "Connect port i2c_scl from port group i2c5 to this pad." }
                      { value: "22", name: "port_i2c5_i2c_sda", desc: "Connect port i2c_sda from port group i2c5 to this pad." }
                      { value: "23", name: "port_uart7_uart_rx", desc: "Connect port uart_rx from port group uart7 to this pad." }
                      { value: "24", name: "port_uart7_uart_tx", desc: "Connect port uart_tx from port group uart7 to this pad." }
                  ]
              }
          ]
      }

      {
          name: PAD_MX_HYPER1_6_CFG
          desc: '''
            Pad signal configuration.
          '''
          swaccess: "rw"
          fields: [
            {
                bits: "0"
                name: chip2pad
                desc: '''
                     The signal that connects to the pads TX driver
                '''
                swaccess: "rw"
                hwaccess: "hro"
                resval: "0"
            },
            {
                bits: "1"
                name: oen
                desc: '''
                     Output enable signal, active low
                '''
                swaccess: "rw"
                hwaccess: "hro"
                resval: "1"
            },
          ]
      }

       {
          name: PAD_MX_HYPER1_6_MUX_SEL
          desc: '''
              Pad signal port multiplex selection for pad pad_mx_hyper1_6. The programmed value defines which port
              is connected to the pad.
          '''
          swaccess: "rw"
          hwaccess: "hro"
          resval: 0
          fields: [
              {
                  bits: "4:0"
                  enum: [
                      { value: "0", name: "register", desc: "Connects the Pad to the internal configuration register."}
                      { value: "1", name: "port_eth0_eth_rst", desc: "Connect port eth_rst from port group eth0 to this pad." }
                      { value: "2", name: "port_eth0_eth_rxck", desc: "Connect port eth_rxck from port group eth0 to this pad." }
                      { value: "3", name: "port_eth0_eth_rxctl", desc: "Connect port eth_rxctl from port group eth0 to this pad." }
                      { value: "4", name: "port_eth0_eth_rxd0", desc: "Connect port eth_rxd0 from port group eth0 to this pad." }
                      { value: "5", name: "port_eth0_eth_rxd1", desc: "Connect port eth_rxd1 from port group eth0 to this pad." }
                      { value: "6", name: "port_eth0_eth_rxd2", desc: "Connect port eth_rxd2 from port group eth0 to this pad." }
                      { value: "7", name: "port_eth0_eth_rxd3", desc: "Connect port eth_rxd3 from port group eth0 to this pad." }
                      { value: "8", name: "port_eth0_eth_txck", desc: "Connect port eth_txck from port group eth0 to this pad." }
                      { value: "9", name: "port_eth0_eth_txctl", desc: "Connect port eth_txctl from port group eth0 to this pad." }
                      { value: "10", name: "port_eth0_eth_txd0", desc: "Connect port eth_txd0 from port group eth0 to this pad." }
                      { value: "11", name: "port_eth0_eth_txd1", desc: "Connect port eth_txd1 from port group eth0 to this pad." }
                      { value: "12", name: "port_eth0_eth_txd2", desc: "Connect port eth_txd2 from port group eth0 to this pad." }
                      { value: "13", name: "port_eth0_eth_txd3", desc: "Connect port eth_txd3 from port group eth0 to this pad." }
                      { value: "14", name: "port_hyper1_hyper_ck", desc: "Connect port hyper_ck from port group hyper1 to this pad." }
                      { value: "15", name: "port_hyper1_hyper_ckn", desc: "Connect port hyper_ckn from port group hyper1 to this pad." }
                      { value: "16", name: "port_hyper1_hyper_cs0", desc: "Connect port hyper_cs0 from port group hyper1 to this pad." }
                      { value: "17", name: "port_hyper1_hyper_cs1", desc: "Connect port hyper_cs1 from port group hyper1 to this pad." }
                      { value: "18", name: "port_hyper1_hyper_dq0_i", desc: "Connect port hyper_dq0_i from port group hyper1 to this pad." }
                      { value: "19", name: "port_hyper1_hyper_rst", desc: "Connect port hyper_rst from port group hyper1 to this pad." }
                      { value: "20", name: "port_hyper1_hyper_rwds", desc: "Connect port hyper_rwds from port group hyper1 to this pad." }
                      { value: "21", name: "port_i2c5_i2c_scl", desc: "Connect port i2c_scl from port group i2c5 to this pad." }
                      { value: "22", name: "port_i2c5_i2c_sda", desc: "Connect port i2c_sda from port group i2c5 to this pad." }
                      { value: "23", name: "port_uart7_uart_rx", desc: "Connect port uart_rx from port group uart7 to this pad." }
                      { value: "24", name: "port_uart7_uart_tx", desc: "Connect port uart_tx from port group uart7 to this pad." }
                  ]
              }
          ]
      }

      {
          name: PAD_MX_HYPER1_7_CFG
          desc: '''
            Pad signal configuration.
          '''
          swaccess: "rw"
          fields: [
            {
                bits: "0"
                name: chip2pad
                desc: '''
                     The signal that connects to the pads TX driver
                '''
                swaccess: "rw"
                hwaccess: "hro"
                resval: "0"
            },
            {
                bits: "1"
                name: oen
                desc: '''
                     Output enable signal, active low
                '''
                swaccess: "rw"
                hwaccess: "hro"
                resval: "1"
            },
          ]
      }

       {
          name: PAD_MX_HYPER1_7_MUX_SEL
          desc: '''
              Pad signal port multiplex selection for pad pad_mx_hyper1_7. The programmed value defines which port
              is connected to the pad.
          '''
          swaccess: "rw"
          hwaccess: "hro"
          resval: 0
          fields: [
              {
                  bits: "4:0"
                  enum: [
                      { value: "0", name: "register", desc: "Connects the Pad to the internal configuration register."}
                      { value: "1", name: "port_eth0_eth_rst", desc: "Connect port eth_rst from port group eth0 to this pad." }
                      { value: "2", name: "port_eth0_eth_rxck", desc: "Connect port eth_rxck from port group eth0 to this pad." }
                      { value: "3", name: "port_eth0_eth_rxctl", desc: "Connect port eth_rxctl from port group eth0 to this pad." }
                      { value: "4", name: "port_eth0_eth_rxd0", desc: "Connect port eth_rxd0 from port group eth0 to this pad." }
                      { value: "5", name: "port_eth0_eth_rxd1", desc: "Connect port eth_rxd1 from port group eth0 to this pad." }
                      { value: "6", name: "port_eth0_eth_rxd2", desc: "Connect port eth_rxd2 from port group eth0 to this pad." }
                      { value: "7", name: "port_eth0_eth_rxd3", desc: "Connect port eth_rxd3 from port group eth0 to this pad." }
                      { value: "8", name: "port_eth0_eth_txck", desc: "Connect port eth_txck from port group eth0 to this pad." }
                      { value: "9", name: "port_eth0_eth_txctl", desc: "Connect port eth_txctl from port group eth0 to this pad." }
                      { value: "10", name: "port_eth0_eth_txd0", desc: "Connect port eth_txd0 from port group eth0 to this pad." }
                      { value: "11", name: "port_eth0_eth_txd1", desc: "Connect port eth_txd1 from port group eth0 to this pad." }
                      { value: "12", name: "port_eth0_eth_txd2", desc: "Connect port eth_txd2 from port group eth0 to this pad." }
                      { value: "13", name: "port_eth0_eth_txd3", desc: "Connect port eth_txd3 from port group eth0 to this pad." }
                      { value: "14", name: "port_hyper1_hyper_ck", desc: "Connect port hyper_ck from port group hyper1 to this pad." }
                      { value: "15", name: "port_hyper1_hyper_ckn", desc: "Connect port hyper_ckn from port group hyper1 to this pad." }
                      { value: "16", name: "port_hyper1_hyper_cs0", desc: "Connect port hyper_cs0 from port group hyper1 to this pad." }
                      { value: "17", name: "port_hyper1_hyper_cs1", desc: "Connect port hyper_cs1 from port group hyper1 to this pad." }
                      { value: "18", name: "port_hyper1_hyper_dq0_i", desc: "Connect port hyper_dq0_i from port group hyper1 to this pad." }
                      { value: "19", name: "port_hyper1_hyper_rst", desc: "Connect port hyper_rst from port group hyper1 to this pad." }
                      { value: "20", name: "port_hyper1_hyper_rwds", desc: "Connect port hyper_rwds from port group hyper1 to this pad." }
                      { value: "21", name: "port_i2c5_i2c_scl", desc: "Connect port i2c_scl from port group i2c5 to this pad." }
                      { value: "22", name: "port_i2c5_i2c_sda", desc: "Connect port i2c_sda from port group i2c5 to this pad." }
                      { value: "23", name: "port_uart7_uart_rx", desc: "Connect port uart_rx from port group uart7 to this pad." }
                      { value: "24", name: "port_uart7_uart_tx", desc: "Connect port uart_tx from port group uart7 to this pad." }
                  ]
              }
          ]
      }

      {
          name: PAD_MX_HYPER1_8_CFG
          desc: '''
            Pad signal configuration.
          '''
          swaccess: "rw"
          fields: [
            {
                bits: "0"
                name: chip2pad
                desc: '''
                     The signal that connects to the pads TX driver
                '''
                swaccess: "rw"
                hwaccess: "hro"
                resval: "0"
            },
            {
                bits: "1"
                name: oen
                desc: '''
                     Output enable signal, active low
                '''
                swaccess: "rw"
                hwaccess: "hro"
                resval: "1"
            },
          ]
      }

       {
          name: PAD_MX_HYPER1_8_MUX_SEL
          desc: '''
              Pad signal port multiplex selection for pad pad_mx_hyper1_8. The programmed value defines which port
              is connected to the pad.
          '''
          swaccess: "rw"
          hwaccess: "hro"
          resval: 0
          fields: [
              {
                  bits: "4:0"
                  enum: [
                      { value: "0", name: "register", desc: "Connects the Pad to the internal configuration register."}
                      { value: "1", name: "port_eth0_eth_rst", desc: "Connect port eth_rst from port group eth0 to this pad." }
                      { value: "2", name: "port_eth0_eth_rxck", desc: "Connect port eth_rxck from port group eth0 to this pad." }
                      { value: "3", name: "port_eth0_eth_rxctl", desc: "Connect port eth_rxctl from port group eth0 to this pad." }
                      { value: "4", name: "port_eth0_eth_rxd0", desc: "Connect port eth_rxd0 from port group eth0 to this pad." }
                      { value: "5", name: "port_eth0_eth_rxd1", desc: "Connect port eth_rxd1 from port group eth0 to this pad." }
                      { value: "6", name: "port_eth0_eth_rxd2", desc: "Connect port eth_rxd2 from port group eth0 to this pad." }
                      { value: "7", name: "port_eth0_eth_rxd3", desc: "Connect port eth_rxd3 from port group eth0 to this pad." }
                      { value: "8", name: "port_eth0_eth_txck", desc: "Connect port eth_txck from port group eth0 to this pad." }
                      { value: "9", name: "port_eth0_eth_txctl", desc: "Connect port eth_txctl from port group eth0 to this pad." }
                      { value: "10", name: "port_eth0_eth_txd0", desc: "Connect port eth_txd0 from port group eth0 to this pad." }
                      { value: "11", name: "port_eth0_eth_txd1", desc: "Connect port eth_txd1 from port group eth0 to this pad." }
                      { value: "12", name: "port_eth0_eth_txd2", desc: "Connect port eth_txd2 from port group eth0 to this pad." }
                      { value: "13", name: "port_eth0_eth_txd3", desc: "Connect port eth_txd3 from port group eth0 to this pad." }
                      { value: "14", name: "port_hyper1_hyper_ck", desc: "Connect port hyper_ck from port group hyper1 to this pad." }
                      { value: "15", name: "port_hyper1_hyper_ckn", desc: "Connect port hyper_ckn from port group hyper1 to this pad." }
                      { value: "16", name: "port_hyper1_hyper_cs0", desc: "Connect port hyper_cs0 from port group hyper1 to this pad." }
                      { value: "17", name: "port_hyper1_hyper_cs1", desc: "Connect port hyper_cs1 from port group hyper1 to this pad." }
                      { value: "18", name: "port_hyper1_hyper_dq0_i", desc: "Connect port hyper_dq0_i from port group hyper1 to this pad." }
                      { value: "19", name: "port_hyper1_hyper_rst", desc: "Connect port hyper_rst from port group hyper1 to this pad." }
                      { value: "20", name: "port_hyper1_hyper_rwds", desc: "Connect port hyper_rwds from port group hyper1 to this pad." }
                      { value: "21", name: "port_i2c5_i2c_scl", desc: "Connect port i2c_scl from port group i2c5 to this pad." }
                      { value: "22", name: "port_i2c5_i2c_sda", desc: "Connect port i2c_sda from port group i2c5 to this pad." }
                      { value: "23", name: "port_uart7_uart_rx", desc: "Connect port uart_rx from port group uart7 to this pad." }
                      { value: "24", name: "port_uart7_uart_tx", desc: "Connect port uart_tx from port group uart7 to this pad." }
                  ]
              }
          ]
      }

      {
          name: PAD_MX_HYPER1_9_CFG
          desc: '''
            Pad signal configuration.
          '''
          swaccess: "rw"
          fields: [
            {
                bits: "0"
                name: chip2pad
                desc: '''
                     The signal that connects to the pads TX driver
                '''
                swaccess: "rw"
                hwaccess: "hro"
                resval: "0"
            },
            {
                bits: "1"
                name: oen
                desc: '''
                     Output enable signal, active low
                '''
                swaccess: "rw"
                hwaccess: "hro"
                resval: "1"
            },
          ]
      }

       {
          name: PAD_MX_HYPER1_9_MUX_SEL
          desc: '''
              Pad signal port multiplex selection for pad pad_mx_hyper1_9. The programmed value defines which port
              is connected to the pad.
          '''
          swaccess: "rw"
          hwaccess: "hro"
          resval: 0
          fields: [
              {
                  bits: "4:0"
                  enum: [
                      { value: "0", name: "register", desc: "Connects the Pad to the internal configuration register."}
                      { value: "1", name: "port_eth0_eth_rst", desc: "Connect port eth_rst from port group eth0 to this pad." }
                      { value: "2", name: "port_eth0_eth_rxck", desc: "Connect port eth_rxck from port group eth0 to this pad." }
                      { value: "3", name: "port_eth0_eth_rxctl", desc: "Connect port eth_rxctl from port group eth0 to this pad." }
                      { value: "4", name: "port_eth0_eth_rxd0", desc: "Connect port eth_rxd0 from port group eth0 to this pad." }
                      { value: "5", name: "port_eth0_eth_rxd1", desc: "Connect port eth_rxd1 from port group eth0 to this pad." }
                      { value: "6", name: "port_eth0_eth_rxd2", desc: "Connect port eth_rxd2 from port group eth0 to this pad." }
                      { value: "7", name: "port_eth0_eth_rxd3", desc: "Connect port eth_rxd3 from port group eth0 to this pad." }
                      { value: "8", name: "port_eth0_eth_txck", desc: "Connect port eth_txck from port group eth0 to this pad." }
                      { value: "9", name: "port_eth0_eth_txctl", desc: "Connect port eth_txctl from port group eth0 to this pad." }
                      { value: "10", name: "port_eth0_eth_txd0", desc: "Connect port eth_txd0 from port group eth0 to this pad." }
                      { value: "11", name: "port_eth0_eth_txd1", desc: "Connect port eth_txd1 from port group eth0 to this pad." }
                      { value: "12", name: "port_eth0_eth_txd2", desc: "Connect port eth_txd2 from port group eth0 to this pad." }
                      { value: "13", name: "port_eth0_eth_txd3", desc: "Connect port eth_txd3 from port group eth0 to this pad." }
                      { value: "14", name: "port_hyper1_hyper_ck", desc: "Connect port hyper_ck from port group hyper1 to this pad." }
                      { value: "15", name: "port_hyper1_hyper_ckn", desc: "Connect port hyper_ckn from port group hyper1 to this pad." }
                      { value: "16", name: "port_hyper1_hyper_cs0", desc: "Connect port hyper_cs0 from port group hyper1 to this pad." }
                      { value: "17", name: "port_hyper1_hyper_cs1", desc: "Connect port hyper_cs1 from port group hyper1 to this pad." }
                      { value: "18", name: "port_hyper1_hyper_dq0_i", desc: "Connect port hyper_dq0_i from port group hyper1 to this pad." }
                      { value: "19", name: "port_hyper1_hyper_rst", desc: "Connect port hyper_rst from port group hyper1 to this pad." }
                      { value: "20", name: "port_hyper1_hyper_rwds", desc: "Connect port hyper_rwds from port group hyper1 to this pad." }
                      { value: "21", name: "port_i2c5_i2c_scl", desc: "Connect port i2c_scl from port group i2c5 to this pad." }
                      { value: "22", name: "port_i2c5_i2c_sda", desc: "Connect port i2c_sda from port group i2c5 to this pad." }
                      { value: "23", name: "port_uart7_uart_rx", desc: "Connect port uart_rx from port group uart7 to this pad." }
                      { value: "24", name: "port_uart7_uart_tx", desc: "Connect port uart_tx from port group uart7 to this pad." }
                  ]
              }
          ]
      }

      {
          name: PAD_MX_HYPER1_10_CFG
          desc: '''
            Pad signal configuration.
          '''
          swaccess: "rw"
          fields: [
            {
                bits: "0"
                name: chip2pad
                desc: '''
                     The signal that connects to the pads TX driver
                '''
                swaccess: "rw"
                hwaccess: "hro"
                resval: "0"
            },
            {
                bits: "1"
                name: oen
                desc: '''
                     Output enable signal, active low
                '''
                swaccess: "rw"
                hwaccess: "hro"
                resval: "1"
            },
          ]
      }

       {
          name: PAD_MX_HYPER1_10_MUX_SEL
          desc: '''
              Pad signal port multiplex selection for pad pad_mx_hyper1_10. The programmed value defines which port
              is connected to the pad.
          '''
          swaccess: "rw"
          hwaccess: "hro"
          resval: 0
          fields: [
              {
                  bits: "4:0"
                  enum: [
                      { value: "0", name: "register", desc: "Connects the Pad to the internal configuration register."}
                      { value: "1", name: "port_eth0_eth_rst", desc: "Connect port eth_rst from port group eth0 to this pad." }
                      { value: "2", name: "port_eth0_eth_rxck", desc: "Connect port eth_rxck from port group eth0 to this pad." }
                      { value: "3", name: "port_eth0_eth_rxctl", desc: "Connect port eth_rxctl from port group eth0 to this pad." }
                      { value: "4", name: "port_eth0_eth_rxd0", desc: "Connect port eth_rxd0 from port group eth0 to this pad." }
                      { value: "5", name: "port_eth0_eth_rxd1", desc: "Connect port eth_rxd1 from port group eth0 to this pad." }
                      { value: "6", name: "port_eth0_eth_rxd2", desc: "Connect port eth_rxd2 from port group eth0 to this pad." }
                      { value: "7", name: "port_eth0_eth_rxd3", desc: "Connect port eth_rxd3 from port group eth0 to this pad." }
                      { value: "8", name: "port_eth0_eth_txck", desc: "Connect port eth_txck from port group eth0 to this pad." }
                      { value: "9", name: "port_eth0_eth_txctl", desc: "Connect port eth_txctl from port group eth0 to this pad." }
                      { value: "10", name: "port_eth0_eth_txd0", desc: "Connect port eth_txd0 from port group eth0 to this pad." }
                      { value: "11", name: "port_eth0_eth_txd1", desc: "Connect port eth_txd1 from port group eth0 to this pad." }
                      { value: "12", name: "port_eth0_eth_txd2", desc: "Connect port eth_txd2 from port group eth0 to this pad." }
                      { value: "13", name: "port_eth0_eth_txd3", desc: "Connect port eth_txd3 from port group eth0 to this pad." }
                      { value: "14", name: "port_hyper1_hyper_ck", desc: "Connect port hyper_ck from port group hyper1 to this pad." }
                      { value: "15", name: "port_hyper1_hyper_ckn", desc: "Connect port hyper_ckn from port group hyper1 to this pad." }
                      { value: "16", name: "port_hyper1_hyper_cs0", desc: "Connect port hyper_cs0 from port group hyper1 to this pad." }
                      { value: "17", name: "port_hyper1_hyper_cs1", desc: "Connect port hyper_cs1 from port group hyper1 to this pad." }
                      { value: "18", name: "port_hyper1_hyper_dq0_i", desc: "Connect port hyper_dq0_i from port group hyper1 to this pad." }
                      { value: "19", name: "port_hyper1_hyper_rst", desc: "Connect port hyper_rst from port group hyper1 to this pad." }
                      { value: "20", name: "port_hyper1_hyper_rwds", desc: "Connect port hyper_rwds from port group hyper1 to this pad." }
                      { value: "21", name: "port_i2c5_i2c_scl", desc: "Connect port i2c_scl from port group i2c5 to this pad." }
                      { value: "22", name: "port_i2c5_i2c_sda", desc: "Connect port i2c_sda from port group i2c5 to this pad." }
                      { value: "23", name: "port_uart7_uart_rx", desc: "Connect port uart_rx from port group uart7 to this pad." }
                      { value: "24", name: "port_uart7_uart_tx", desc: "Connect port uart_tx from port group uart7 to this pad." }
                  ]
              }
          ]
      }

      {
          name: PAD_MX_HYPER1_11_CFG
          desc: '''
            Pad signal configuration.
          '''
          swaccess: "rw"
          fields: [
            {
                bits: "0"
                name: chip2pad
                desc: '''
                     The signal that connects to the pads TX driver
                '''
                swaccess: "rw"
                hwaccess: "hro"
                resval: "0"
            },
            {
                bits: "1"
                name: oen
                desc: '''
                     Output enable signal, active low
                '''
                swaccess: "rw"
                hwaccess: "hro"
                resval: "1"
            },
          ]
      }

       {
          name: PAD_MX_HYPER1_11_MUX_SEL
          desc: '''
              Pad signal port multiplex selection for pad pad_mx_hyper1_11. The programmed value defines which port
              is connected to the pad.
          '''
          swaccess: "rw"
          hwaccess: "hro"
          resval: 0
          fields: [
              {
                  bits: "4:0"
                  enum: [
                      { value: "0", name: "register", desc: "Connects the Pad to the internal configuration register."}
                      { value: "1", name: "port_eth0_eth_rst", desc: "Connect port eth_rst from port group eth0 to this pad." }
                      { value: "2", name: "port_eth0_eth_rxck", desc: "Connect port eth_rxck from port group eth0 to this pad." }
                      { value: "3", name: "port_eth0_eth_rxctl", desc: "Connect port eth_rxctl from port group eth0 to this pad." }
                      { value: "4", name: "port_eth0_eth_rxd0", desc: "Connect port eth_rxd0 from port group eth0 to this pad." }
                      { value: "5", name: "port_eth0_eth_rxd1", desc: "Connect port eth_rxd1 from port group eth0 to this pad." }
                      { value: "6", name: "port_eth0_eth_rxd2", desc: "Connect port eth_rxd2 from port group eth0 to this pad." }
                      { value: "7", name: "port_eth0_eth_rxd3", desc: "Connect port eth_rxd3 from port group eth0 to this pad." }
                      { value: "8", name: "port_eth0_eth_txck", desc: "Connect port eth_txck from port group eth0 to this pad." }
                      { value: "9", name: "port_eth0_eth_txctl", desc: "Connect port eth_txctl from port group eth0 to this pad." }
                      { value: "10", name: "port_eth0_eth_txd0", desc: "Connect port eth_txd0 from port group eth0 to this pad." }
                      { value: "11", name: "port_eth0_eth_txd1", desc: "Connect port eth_txd1 from port group eth0 to this pad." }
                      { value: "12", name: "port_eth0_eth_txd2", desc: "Connect port eth_txd2 from port group eth0 to this pad." }
                      { value: "13", name: "port_eth0_eth_txd3", desc: "Connect port eth_txd3 from port group eth0 to this pad." }
                      { value: "14", name: "port_hyper1_hyper_ck", desc: "Connect port hyper_ck from port group hyper1 to this pad." }
                      { value: "15", name: "port_hyper1_hyper_ckn", desc: "Connect port hyper_ckn from port group hyper1 to this pad." }
                      { value: "16", name: "port_hyper1_hyper_cs0", desc: "Connect port hyper_cs0 from port group hyper1 to this pad." }
                      { value: "17", name: "port_hyper1_hyper_cs1", desc: "Connect port hyper_cs1 from port group hyper1 to this pad." }
                      { value: "18", name: "port_hyper1_hyper_dq0_i", desc: "Connect port hyper_dq0_i from port group hyper1 to this pad." }
                      { value: "19", name: "port_hyper1_hyper_rst", desc: "Connect port hyper_rst from port group hyper1 to this pad." }
                      { value: "20", name: "port_hyper1_hyper_rwds", desc: "Connect port hyper_rwds from port group hyper1 to this pad." }
                      { value: "21", name: "port_i2c5_i2c_scl", desc: "Connect port i2c_scl from port group i2c5 to this pad." }
                      { value: "22", name: "port_i2c5_i2c_sda", desc: "Connect port i2c_sda from port group i2c5 to this pad." }
                      { value: "23", name: "port_uart7_uart_rx", desc: "Connect port uart_rx from port group uart7 to this pad." }
                      { value: "24", name: "port_uart7_uart_tx", desc: "Connect port uart_tx from port group uart7 to this pad." }
                  ]
              }
          ]
      }

      {
          name: PAD_MX_HYPER1_12_CFG
          desc: '''
            Pad signal configuration.
          '''
          swaccess: "rw"
          fields: [
            {
                bits: "0"
                name: chip2pad
                desc: '''
                     The signal that connects to the pads TX driver
                '''
                swaccess: "rw"
                hwaccess: "hro"
                resval: "0"
            },
            {
                bits: "1"
                name: oen
                desc: '''
                     Output enable signal, active low
                '''
                swaccess: "rw"
                hwaccess: "hro"
                resval: "1"
            },
          ]
      }

       {
          name: PAD_MX_HYPER1_12_MUX_SEL
          desc: '''
              Pad signal port multiplex selection for pad pad_mx_hyper1_12. The programmed value defines which port
              is connected to the pad.
          '''
          swaccess: "rw"
          hwaccess: "hro"
          resval: 0
          fields: [
              {
                  bits: "4:0"
                  enum: [
                      { value: "0", name: "register", desc: "Connects the Pad to the internal configuration register."}
                      { value: "1", name: "port_eth0_eth_rst", desc: "Connect port eth_rst from port group eth0 to this pad." }
                      { value: "2", name: "port_eth0_eth_rxck", desc: "Connect port eth_rxck from port group eth0 to this pad." }
                      { value: "3", name: "port_eth0_eth_rxctl", desc: "Connect port eth_rxctl from port group eth0 to this pad." }
                      { value: "4", name: "port_eth0_eth_rxd0", desc: "Connect port eth_rxd0 from port group eth0 to this pad." }
                      { value: "5", name: "port_eth0_eth_rxd1", desc: "Connect port eth_rxd1 from port group eth0 to this pad." }
                      { value: "6", name: "port_eth0_eth_rxd2", desc: "Connect port eth_rxd2 from port group eth0 to this pad." }
                      { value: "7", name: "port_eth0_eth_rxd3", desc: "Connect port eth_rxd3 from port group eth0 to this pad." }
                      { value: "8", name: "port_eth0_eth_txck", desc: "Connect port eth_txck from port group eth0 to this pad." }
                      { value: "9", name: "port_eth0_eth_txctl", desc: "Connect port eth_txctl from port group eth0 to this pad." }
                      { value: "10", name: "port_eth0_eth_txd0", desc: "Connect port eth_txd0 from port group eth0 to this pad." }
                      { value: "11", name: "port_eth0_eth_txd1", desc: "Connect port eth_txd1 from port group eth0 to this pad." }
                      { value: "12", name: "port_eth0_eth_txd2", desc: "Connect port eth_txd2 from port group eth0 to this pad." }
                      { value: "13", name: "port_eth0_eth_txd3", desc: "Connect port eth_txd3 from port group eth0 to this pad." }
                      { value: "14", name: "port_hyper1_hyper_ck", desc: "Connect port hyper_ck from port group hyper1 to this pad." }
                      { value: "15", name: "port_hyper1_hyper_ckn", desc: "Connect port hyper_ckn from port group hyper1 to this pad." }
                      { value: "16", name: "port_hyper1_hyper_cs0", desc: "Connect port hyper_cs0 from port group hyper1 to this pad." }
                      { value: "17", name: "port_hyper1_hyper_cs1", desc: "Connect port hyper_cs1 from port group hyper1 to this pad." }
                      { value: "18", name: "port_hyper1_hyper_dq0_i", desc: "Connect port hyper_dq0_i from port group hyper1 to this pad." }
                      { value: "19", name: "port_hyper1_hyper_rst", desc: "Connect port hyper_rst from port group hyper1 to this pad." }
                      { value: "20", name: "port_hyper1_hyper_rwds", desc: "Connect port hyper_rwds from port group hyper1 to this pad." }
                      { value: "21", name: "port_i2c5_i2c_scl", desc: "Connect port i2c_scl from port group i2c5 to this pad." }
                      { value: "22", name: "port_i2c5_i2c_sda", desc: "Connect port i2c_sda from port group i2c5 to this pad." }
                      { value: "23", name: "port_uart7_uart_rx", desc: "Connect port uart_rx from port group uart7 to this pad." }
                      { value: "24", name: "port_uart7_uart_tx", desc: "Connect port uart_tx from port group uart7 to this pad." }
                  ]
              }
          ]
      }

    ]
}
