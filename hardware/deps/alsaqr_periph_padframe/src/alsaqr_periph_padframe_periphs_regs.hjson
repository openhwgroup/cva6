
{
    # File auto-generated by Padrick 0.1.0.post0.dev39+g0a36a20
    name: "alsaqr_periph_padframe_periphs_config"
    clock_primary: "clk_i"
    reset_primary: "rst_ni"
    bus_interfaces: [
        { protocol: "reg_iface", direction: "device"}
    ]
    regwidth: 32,
    registers: [
        {skipto: "0x0"},
























































      {
          name: PAD_IO_A_00_CFG
          desc: '''
            Pad signal configuration.
          '''
          swaccess: "rw"
          fields: [
            {
                bits: "0"
                name: chip2pad
                desc: '''
                     The signal that connects to the pads TX driver
                '''
                swaccess: "rw"
                hwaccess: "hro"
                resval: "0"
            },
            {
                bits: "1"
                name: oen
                desc: '''
                     Output enable signal, active low
                '''
                swaccess: "rw"
                hwaccess: "hro"
                resval: "1"
            },
          ]
      }

       {
          name: PAD_IO_A_00_MUX_SEL
          desc: '''
              Pad signal port multiplex selection for pad pad_io_a_00. The programmed value defines which port
              is connected to the pad.
          '''
          swaccess: "rw"
          hwaccess: "hro"
          resval: 0
          fields: [
              {
                  bits: "3:0"
                  enum: [
                      { value: "0", name: "register", desc: "Connects the Pad to the internal configuration register."}
                      { value: "1", name: "port_i2c0_i2c_scl", desc: "Connect port i2c_scl from port group i2c0 to this pad." }
                      { value: "2", name: "port_i2c0_i2c_sda", desc: "Connect port i2c_sda from port group i2c0 to this pad." }
                      { value: "3", name: "port_i2c1_i2c_scl", desc: "Connect port i2c_scl from port group i2c1 to this pad." }
                      { value: "4", name: "port_i2c1_i2c_sda", desc: "Connect port i2c_sda from port group i2c1 to this pad." }
                      { value: "5", name: "port_i2c2_i2c_scl", desc: "Connect port i2c_scl from port group i2c2 to this pad." }
                      { value: "6", name: "port_i2c2_i2c_sda", desc: "Connect port i2c_sda from port group i2c2 to this pad." }
                      { value: "7", name: "port_spi0_spi_cs", desc: "Connect port spi_cs from port group spi0 to this pad." }
                      { value: "8", name: "port_spi0_spi_miso", desc: "Connect port spi_miso from port group spi0 to this pad." }
                      { value: "9", name: "port_spi0_spi_mosi", desc: "Connect port spi_mosi from port group spi0 to this pad." }
                      { value: "10", name: "port_spi0_spi_sck", desc: "Connect port spi_sck from port group spi0 to this pad." }
                      { value: "11", name: "port_spi1_spi_cs", desc: "Connect port spi_cs from port group spi1 to this pad." }
                      { value: "12", name: "port_spi1_spi_miso", desc: "Connect port spi_miso from port group spi1 to this pad." }
                      { value: "13", name: "port_spi1_spi_mosi", desc: "Connect port spi_mosi from port group spi1 to this pad." }
                      { value: "14", name: "port_spi1_spi_sck", desc: "Connect port spi_sck from port group spi1 to this pad." }
                      { value: "15", name: "port_spi1_cs1_spi1_cs1", desc: "Connect port spi1_cs1 from port group spi1_cs1 to this pad." }
                  ]
              }
          ]
      }

      {
          name: PAD_IO_A_01_CFG
          desc: '''
            Pad signal configuration.
          '''
          swaccess: "rw"
          fields: [
            {
                bits: "0"
                name: chip2pad
                desc: '''
                     The signal that connects to the pads TX driver
                '''
                swaccess: "rw"
                hwaccess: "hro"
                resval: "0"
            },
            {
                bits: "1"
                name: oen
                desc: '''
                     Output enable signal, active low
                '''
                swaccess: "rw"
                hwaccess: "hro"
                resval: "1"
            },
          ]
      }

       {
          name: PAD_IO_A_01_MUX_SEL
          desc: '''
              Pad signal port multiplex selection for pad pad_io_a_01. The programmed value defines which port
              is connected to the pad.
          '''
          swaccess: "rw"
          hwaccess: "hro"
          resval: 0
          fields: [
              {
                  bits: "3:0"
                  enum: [
                      { value: "0", name: "register", desc: "Connects the Pad to the internal configuration register."}
                      { value: "1", name: "port_i2c0_i2c_scl", desc: "Connect port i2c_scl from port group i2c0 to this pad." }
                      { value: "2", name: "port_i2c0_i2c_sda", desc: "Connect port i2c_sda from port group i2c0 to this pad." }
                      { value: "3", name: "port_i2c1_i2c_scl", desc: "Connect port i2c_scl from port group i2c1 to this pad." }
                      { value: "4", name: "port_i2c1_i2c_sda", desc: "Connect port i2c_sda from port group i2c1 to this pad." }
                      { value: "5", name: "port_i2c2_i2c_scl", desc: "Connect port i2c_scl from port group i2c2 to this pad." }
                      { value: "6", name: "port_i2c2_i2c_sda", desc: "Connect port i2c_sda from port group i2c2 to this pad." }
                      { value: "7", name: "port_spi0_spi_cs", desc: "Connect port spi_cs from port group spi0 to this pad." }
                      { value: "8", name: "port_spi0_spi_miso", desc: "Connect port spi_miso from port group spi0 to this pad." }
                      { value: "9", name: "port_spi0_spi_mosi", desc: "Connect port spi_mosi from port group spi0 to this pad." }
                      { value: "10", name: "port_spi0_spi_sck", desc: "Connect port spi_sck from port group spi0 to this pad." }
                      { value: "11", name: "port_spi1_spi_cs", desc: "Connect port spi_cs from port group spi1 to this pad." }
                      { value: "12", name: "port_spi1_spi_miso", desc: "Connect port spi_miso from port group spi1 to this pad." }
                      { value: "13", name: "port_spi1_spi_mosi", desc: "Connect port spi_mosi from port group spi1 to this pad." }
                      { value: "14", name: "port_spi1_spi_sck", desc: "Connect port spi_sck from port group spi1 to this pad." }
                      { value: "15", name: "port_spi1_cs1_spi1_cs1", desc: "Connect port spi1_cs1 from port group spi1_cs1 to this pad." }
                  ]
              }
          ]
      }

      {
          name: PAD_IO_A_02_CFG
          desc: '''
            Pad signal configuration.
          '''
          swaccess: "rw"
          fields: [
            {
                bits: "0"
                name: chip2pad
                desc: '''
                     The signal that connects to the pads TX driver
                '''
                swaccess: "rw"
                hwaccess: "hro"
                resval: "0"
            },
            {
                bits: "1"
                name: oen
                desc: '''
                     Output enable signal, active low
                '''
                swaccess: "rw"
                hwaccess: "hro"
                resval: "1"
            },
          ]
      }

       {
          name: PAD_IO_A_02_MUX_SEL
          desc: '''
              Pad signal port multiplex selection for pad pad_io_a_02. The programmed value defines which port
              is connected to the pad.
          '''
          swaccess: "rw"
          hwaccess: "hro"
          resval: 0
          fields: [
              {
                  bits: "3:0"
                  enum: [
                      { value: "0", name: "register", desc: "Connects the Pad to the internal configuration register."}
                      { value: "1", name: "port_i2c0_i2c_scl", desc: "Connect port i2c_scl from port group i2c0 to this pad." }
                      { value: "2", name: "port_i2c0_i2c_sda", desc: "Connect port i2c_sda from port group i2c0 to this pad." }
                      { value: "3", name: "port_i2c1_i2c_scl", desc: "Connect port i2c_scl from port group i2c1 to this pad." }
                      { value: "4", name: "port_i2c1_i2c_sda", desc: "Connect port i2c_sda from port group i2c1 to this pad." }
                      { value: "5", name: "port_i2c2_i2c_scl", desc: "Connect port i2c_scl from port group i2c2 to this pad." }
                      { value: "6", name: "port_i2c2_i2c_sda", desc: "Connect port i2c_sda from port group i2c2 to this pad." }
                      { value: "7", name: "port_spi0_spi_cs", desc: "Connect port spi_cs from port group spi0 to this pad." }
                      { value: "8", name: "port_spi0_spi_miso", desc: "Connect port spi_miso from port group spi0 to this pad." }
                      { value: "9", name: "port_spi0_spi_mosi", desc: "Connect port spi_mosi from port group spi0 to this pad." }
                      { value: "10", name: "port_spi0_spi_sck", desc: "Connect port spi_sck from port group spi0 to this pad." }
                      { value: "11", name: "port_spi1_spi_cs", desc: "Connect port spi_cs from port group spi1 to this pad." }
                      { value: "12", name: "port_spi1_spi_miso", desc: "Connect port spi_miso from port group spi1 to this pad." }
                      { value: "13", name: "port_spi1_spi_mosi", desc: "Connect port spi_mosi from port group spi1 to this pad." }
                      { value: "14", name: "port_spi1_spi_sck", desc: "Connect port spi_sck from port group spi1 to this pad." }
                      { value: "15", name: "port_spi1_cs1_spi1_cs1", desc: "Connect port spi1_cs1 from port group spi1_cs1 to this pad." }
                  ]
              }
          ]
      }

      {
          name: PAD_IO_A_03_CFG
          desc: '''
            Pad signal configuration.
          '''
          swaccess: "rw"
          fields: [
            {
                bits: "0"
                name: chip2pad
                desc: '''
                     The signal that connects to the pads TX driver
                '''
                swaccess: "rw"
                hwaccess: "hro"
                resval: "0"
            },
            {
                bits: "1"
                name: oen
                desc: '''
                     Output enable signal, active low
                '''
                swaccess: "rw"
                hwaccess: "hro"
                resval: "1"
            },
          ]
      }

       {
          name: PAD_IO_A_03_MUX_SEL
          desc: '''
              Pad signal port multiplex selection for pad pad_io_a_03. The programmed value defines which port
              is connected to the pad.
          '''
          swaccess: "rw"
          hwaccess: "hro"
          resval: 0
          fields: [
              {
                  bits: "3:0"
                  enum: [
                      { value: "0", name: "register", desc: "Connects the Pad to the internal configuration register."}
                      { value: "1", name: "port_i2c0_i2c_scl", desc: "Connect port i2c_scl from port group i2c0 to this pad." }
                      { value: "2", name: "port_i2c0_i2c_sda", desc: "Connect port i2c_sda from port group i2c0 to this pad." }
                      { value: "3", name: "port_i2c1_i2c_scl", desc: "Connect port i2c_scl from port group i2c1 to this pad." }
                      { value: "4", name: "port_i2c1_i2c_sda", desc: "Connect port i2c_sda from port group i2c1 to this pad." }
                      { value: "5", name: "port_i2c2_i2c_scl", desc: "Connect port i2c_scl from port group i2c2 to this pad." }
                      { value: "6", name: "port_i2c2_i2c_sda", desc: "Connect port i2c_sda from port group i2c2 to this pad." }
                      { value: "7", name: "port_spi0_spi_cs", desc: "Connect port spi_cs from port group spi0 to this pad." }
                      { value: "8", name: "port_spi0_spi_miso", desc: "Connect port spi_miso from port group spi0 to this pad." }
                      { value: "9", name: "port_spi0_spi_mosi", desc: "Connect port spi_mosi from port group spi0 to this pad." }
                      { value: "10", name: "port_spi0_spi_sck", desc: "Connect port spi_sck from port group spi0 to this pad." }
                      { value: "11", name: "port_spi1_spi_cs", desc: "Connect port spi_cs from port group spi1 to this pad." }
                      { value: "12", name: "port_spi1_spi_miso", desc: "Connect port spi_miso from port group spi1 to this pad." }
                      { value: "13", name: "port_spi1_spi_mosi", desc: "Connect port spi_mosi from port group spi1 to this pad." }
                      { value: "14", name: "port_spi1_spi_sck", desc: "Connect port spi_sck from port group spi1 to this pad." }
                      { value: "15", name: "port_spi1_cs1_spi1_cs1", desc: "Connect port spi1_cs1 from port group spi1_cs1 to this pad." }
                  ]
              }
          ]
      }

      {
          name: PAD_IO_A_04_CFG
          desc: '''
            Pad signal configuration.
          '''
          swaccess: "rw"
          fields: [
            {
                bits: "0"
                name: chip2pad
                desc: '''
                     The signal that connects to the pads TX driver
                '''
                swaccess: "rw"
                hwaccess: "hro"
                resval: "0"
            },
            {
                bits: "1"
                name: oen
                desc: '''
                     Output enable signal, active low
                '''
                swaccess: "rw"
                hwaccess: "hro"
                resval: "1"
            },
          ]
      }

       {
          name: PAD_IO_A_04_MUX_SEL
          desc: '''
              Pad signal port multiplex selection for pad pad_io_a_04. The programmed value defines which port
              is connected to the pad.
          '''
          swaccess: "rw"
          hwaccess: "hro"
          resval: 0
          fields: [
              {
                  bits: "3:0"
                  enum: [
                      { value: "0", name: "register", desc: "Connects the Pad to the internal configuration register."}
                      { value: "1", name: "port_i2c0_i2c_scl", desc: "Connect port i2c_scl from port group i2c0 to this pad." }
                      { value: "2", name: "port_i2c0_i2c_sda", desc: "Connect port i2c_sda from port group i2c0 to this pad." }
                      { value: "3", name: "port_i2c1_i2c_scl", desc: "Connect port i2c_scl from port group i2c1 to this pad." }
                      { value: "4", name: "port_i2c1_i2c_sda", desc: "Connect port i2c_sda from port group i2c1 to this pad." }
                      { value: "5", name: "port_i2c2_i2c_scl", desc: "Connect port i2c_scl from port group i2c2 to this pad." }
                      { value: "6", name: "port_i2c2_i2c_sda", desc: "Connect port i2c_sda from port group i2c2 to this pad." }
                      { value: "7", name: "port_spi0_spi_cs", desc: "Connect port spi_cs from port group spi0 to this pad." }
                      { value: "8", name: "port_spi0_spi_miso", desc: "Connect port spi_miso from port group spi0 to this pad." }
                      { value: "9", name: "port_spi0_spi_mosi", desc: "Connect port spi_mosi from port group spi0 to this pad." }
                      { value: "10", name: "port_spi0_spi_sck", desc: "Connect port spi_sck from port group spi0 to this pad." }
                      { value: "11", name: "port_spi1_spi_cs", desc: "Connect port spi_cs from port group spi1 to this pad." }
                      { value: "12", name: "port_spi1_spi_miso", desc: "Connect port spi_miso from port group spi1 to this pad." }
                      { value: "13", name: "port_spi1_spi_mosi", desc: "Connect port spi_mosi from port group spi1 to this pad." }
                      { value: "14", name: "port_spi1_spi_sck", desc: "Connect port spi_sck from port group spi1 to this pad." }
                      { value: "15", name: "port_spi1_cs1_spi1_cs1", desc: "Connect port spi1_cs1 from port group spi1_cs1 to this pad." }
                  ]
              }
          ]
      }

      {
          name: PAD_IO_A_05_CFG
          desc: '''
            Pad signal configuration.
          '''
          swaccess: "rw"
          fields: [
            {
                bits: "0"
                name: chip2pad
                desc: '''
                     The signal that connects to the pads TX driver
                '''
                swaccess: "rw"
                hwaccess: "hro"
                resval: "0"
            },
            {
                bits: "1"
                name: oen
                desc: '''
                     Output enable signal, active low
                '''
                swaccess: "rw"
                hwaccess: "hro"
                resval: "1"
            },
          ]
      }

       {
          name: PAD_IO_A_05_MUX_SEL
          desc: '''
              Pad signal port multiplex selection for pad pad_io_a_05. The programmed value defines which port
              is connected to the pad.
          '''
          swaccess: "rw"
          hwaccess: "hro"
          resval: 0
          fields: [
              {
                  bits: "3:0"
                  enum: [
                      { value: "0", name: "register", desc: "Connects the Pad to the internal configuration register."}
                      { value: "1", name: "port_i2c0_i2c_scl", desc: "Connect port i2c_scl from port group i2c0 to this pad." }
                      { value: "2", name: "port_i2c0_i2c_sda", desc: "Connect port i2c_sda from port group i2c0 to this pad." }
                      { value: "3", name: "port_i2c1_i2c_scl", desc: "Connect port i2c_scl from port group i2c1 to this pad." }
                      { value: "4", name: "port_i2c1_i2c_sda", desc: "Connect port i2c_sda from port group i2c1 to this pad." }
                      { value: "5", name: "port_i2c2_i2c_scl", desc: "Connect port i2c_scl from port group i2c2 to this pad." }
                      { value: "6", name: "port_i2c2_i2c_sda", desc: "Connect port i2c_sda from port group i2c2 to this pad." }
                      { value: "7", name: "port_spi0_spi_cs", desc: "Connect port spi_cs from port group spi0 to this pad." }
                      { value: "8", name: "port_spi0_spi_miso", desc: "Connect port spi_miso from port group spi0 to this pad." }
                      { value: "9", name: "port_spi0_spi_mosi", desc: "Connect port spi_mosi from port group spi0 to this pad." }
                      { value: "10", name: "port_spi0_spi_sck", desc: "Connect port spi_sck from port group spi0 to this pad." }
                      { value: "11", name: "port_spi1_spi_cs", desc: "Connect port spi_cs from port group spi1 to this pad." }
                      { value: "12", name: "port_spi1_spi_miso", desc: "Connect port spi_miso from port group spi1 to this pad." }
                      { value: "13", name: "port_spi1_spi_mosi", desc: "Connect port spi_mosi from port group spi1 to this pad." }
                      { value: "14", name: "port_spi1_spi_sck", desc: "Connect port spi_sck from port group spi1 to this pad." }
                      { value: "15", name: "port_spi1_cs1_spi1_cs1", desc: "Connect port spi1_cs1 from port group spi1_cs1 to this pad." }
                  ]
              }
          ]
      }

      {
          name: PAD_IO_A_06_CFG
          desc: '''
            Pad signal configuration.
          '''
          swaccess: "rw"
          fields: [
            {
                bits: "0"
                name: chip2pad
                desc: '''
                     The signal that connects to the pads TX driver
                '''
                swaccess: "rw"
                hwaccess: "hro"
                resval: "0"
            },
            {
                bits: "1"
                name: oen
                desc: '''
                     Output enable signal, active low
                '''
                swaccess: "rw"
                hwaccess: "hro"
                resval: "1"
            },
          ]
      }

       {
          name: PAD_IO_A_06_MUX_SEL
          desc: '''
              Pad signal port multiplex selection for pad pad_io_a_06. The programmed value defines which port
              is connected to the pad.
          '''
          swaccess: "rw"
          hwaccess: "hro"
          resval: 0
          fields: [
              {
                  bits: "3:0"
                  enum: [
                      { value: "0", name: "register", desc: "Connects the Pad to the internal configuration register."}
                      { value: "1", name: "port_i2c0_i2c_scl", desc: "Connect port i2c_scl from port group i2c0 to this pad." }
                      { value: "2", name: "port_i2c0_i2c_sda", desc: "Connect port i2c_sda from port group i2c0 to this pad." }
                      { value: "3", name: "port_i2c1_i2c_scl", desc: "Connect port i2c_scl from port group i2c1 to this pad." }
                      { value: "4", name: "port_i2c1_i2c_sda", desc: "Connect port i2c_sda from port group i2c1 to this pad." }
                      { value: "5", name: "port_i2c2_i2c_scl", desc: "Connect port i2c_scl from port group i2c2 to this pad." }
                      { value: "6", name: "port_i2c2_i2c_sda", desc: "Connect port i2c_sda from port group i2c2 to this pad." }
                      { value: "7", name: "port_spi0_spi_cs", desc: "Connect port spi_cs from port group spi0 to this pad." }
                      { value: "8", name: "port_spi0_spi_miso", desc: "Connect port spi_miso from port group spi0 to this pad." }
                      { value: "9", name: "port_spi0_spi_mosi", desc: "Connect port spi_mosi from port group spi0 to this pad." }
                      { value: "10", name: "port_spi0_spi_sck", desc: "Connect port spi_sck from port group spi0 to this pad." }
                      { value: "11", name: "port_spi1_spi_cs", desc: "Connect port spi_cs from port group spi1 to this pad." }
                      { value: "12", name: "port_spi1_spi_miso", desc: "Connect port spi_miso from port group spi1 to this pad." }
                      { value: "13", name: "port_spi1_spi_mosi", desc: "Connect port spi_mosi from port group spi1 to this pad." }
                      { value: "14", name: "port_spi1_spi_sck", desc: "Connect port spi_sck from port group spi1 to this pad." }
                      { value: "15", name: "port_spi1_cs1_spi1_cs1", desc: "Connect port spi1_cs1 from port group spi1_cs1 to this pad." }
                  ]
              }
          ]
      }

      {
          name: PAD_IO_A_07_CFG
          desc: '''
            Pad signal configuration.
          '''
          swaccess: "rw"
          fields: [
            {
                bits: "0"
                name: chip2pad
                desc: '''
                     The signal that connects to the pads TX driver
                '''
                swaccess: "rw"
                hwaccess: "hro"
                resval: "0"
            },
            {
                bits: "1"
                name: oen
                desc: '''
                     Output enable signal, active low
                '''
                swaccess: "rw"
                hwaccess: "hro"
                resval: "1"
            },
          ]
      }

       {
          name: PAD_IO_A_07_MUX_SEL
          desc: '''
              Pad signal port multiplex selection for pad pad_io_a_07. The programmed value defines which port
              is connected to the pad.
          '''
          swaccess: "rw"
          hwaccess: "hro"
          resval: 0
          fields: [
              {
                  bits: "3:0"
                  enum: [
                      { value: "0", name: "register", desc: "Connects the Pad to the internal configuration register."}
                      { value: "1", name: "port_i2c0_i2c_scl", desc: "Connect port i2c_scl from port group i2c0 to this pad." }
                      { value: "2", name: "port_i2c0_i2c_sda", desc: "Connect port i2c_sda from port group i2c0 to this pad." }
                      { value: "3", name: "port_i2c1_i2c_scl", desc: "Connect port i2c_scl from port group i2c1 to this pad." }
                      { value: "4", name: "port_i2c1_i2c_sda", desc: "Connect port i2c_sda from port group i2c1 to this pad." }
                      { value: "5", name: "port_i2c2_i2c_scl", desc: "Connect port i2c_scl from port group i2c2 to this pad." }
                      { value: "6", name: "port_i2c2_i2c_sda", desc: "Connect port i2c_sda from port group i2c2 to this pad." }
                      { value: "7", name: "port_spi0_spi_cs", desc: "Connect port spi_cs from port group spi0 to this pad." }
                      { value: "8", name: "port_spi0_spi_miso", desc: "Connect port spi_miso from port group spi0 to this pad." }
                      { value: "9", name: "port_spi0_spi_mosi", desc: "Connect port spi_mosi from port group spi0 to this pad." }
                      { value: "10", name: "port_spi0_spi_sck", desc: "Connect port spi_sck from port group spi0 to this pad." }
                      { value: "11", name: "port_spi1_spi_cs", desc: "Connect port spi_cs from port group spi1 to this pad." }
                      { value: "12", name: "port_spi1_spi_miso", desc: "Connect port spi_miso from port group spi1 to this pad." }
                      { value: "13", name: "port_spi1_spi_mosi", desc: "Connect port spi_mosi from port group spi1 to this pad." }
                      { value: "14", name: "port_spi1_spi_sck", desc: "Connect port spi_sck from port group spi1 to this pad." }
                      { value: "15", name: "port_spi1_cs1_spi1_cs1", desc: "Connect port spi1_cs1 from port group spi1_cs1 to this pad." }
                  ]
              }
          ]
      }

      {
          name: PAD_IO_A_08_CFG
          desc: '''
            Pad signal configuration.
          '''
          swaccess: "rw"
          fields: [
            {
                bits: "0"
                name: chip2pad
                desc: '''
                     The signal that connects to the pads TX driver
                '''
                swaccess: "rw"
                hwaccess: "hro"
                resval: "0"
            },
            {
                bits: "1"
                name: oen
                desc: '''
                     Output enable signal, active low
                '''
                swaccess: "rw"
                hwaccess: "hro"
                resval: "1"
            },
          ]
      }

       {
          name: PAD_IO_A_08_MUX_SEL
          desc: '''
              Pad signal port multiplex selection for pad pad_io_a_08. The programmed value defines which port
              is connected to the pad.
          '''
          swaccess: "rw"
          hwaccess: "hro"
          resval: 0
          fields: [
              {
                  bits: "3:0"
                  enum: [
                      { value: "0", name: "register", desc: "Connects the Pad to the internal configuration register."}
                      { value: "1", name: "port_i2c0_i2c_scl", desc: "Connect port i2c_scl from port group i2c0 to this pad." }
                      { value: "2", name: "port_i2c0_i2c_sda", desc: "Connect port i2c_sda from port group i2c0 to this pad." }
                      { value: "3", name: "port_i2c1_i2c_scl", desc: "Connect port i2c_scl from port group i2c1 to this pad." }
                      { value: "4", name: "port_i2c1_i2c_sda", desc: "Connect port i2c_sda from port group i2c1 to this pad." }
                      { value: "5", name: "port_i2c2_i2c_scl", desc: "Connect port i2c_scl from port group i2c2 to this pad." }
                      { value: "6", name: "port_i2c2_i2c_sda", desc: "Connect port i2c_sda from port group i2c2 to this pad." }
                      { value: "7", name: "port_spi0_spi_cs", desc: "Connect port spi_cs from port group spi0 to this pad." }
                      { value: "8", name: "port_spi0_spi_miso", desc: "Connect port spi_miso from port group spi0 to this pad." }
                      { value: "9", name: "port_spi0_spi_mosi", desc: "Connect port spi_mosi from port group spi0 to this pad." }
                      { value: "10", name: "port_spi0_spi_sck", desc: "Connect port spi_sck from port group spi0 to this pad." }
                      { value: "11", name: "port_spi1_spi_cs", desc: "Connect port spi_cs from port group spi1 to this pad." }
                      { value: "12", name: "port_spi1_spi_miso", desc: "Connect port spi_miso from port group spi1 to this pad." }
                      { value: "13", name: "port_spi1_spi_mosi", desc: "Connect port spi_mosi from port group spi1 to this pad." }
                      { value: "14", name: "port_spi1_spi_sck", desc: "Connect port spi_sck from port group spi1 to this pad." }
                      { value: "15", name: "port_spi1_cs1_spi1_cs1", desc: "Connect port spi1_cs1 from port group spi1_cs1 to this pad." }
                  ]
              }
          ]
      }

      {
          name: PAD_IO_A_09_CFG
          desc: '''
            Pad signal configuration.
          '''
          swaccess: "rw"
          fields: [
            {
                bits: "0"
                name: chip2pad
                desc: '''
                     The signal that connects to the pads TX driver
                '''
                swaccess: "rw"
                hwaccess: "hro"
                resval: "0"
            },
            {
                bits: "1"
                name: oen
                desc: '''
                     Output enable signal, active low
                '''
                swaccess: "rw"
                hwaccess: "hro"
                resval: "1"
            },
          ]
      }

       {
          name: PAD_IO_A_09_MUX_SEL
          desc: '''
              Pad signal port multiplex selection for pad pad_io_a_09. The programmed value defines which port
              is connected to the pad.
          '''
          swaccess: "rw"
          hwaccess: "hro"
          resval: 0
          fields: [
              {
                  bits: "3:0"
                  enum: [
                      { value: "0", name: "register", desc: "Connects the Pad to the internal configuration register."}
                      { value: "1", name: "port_i2c0_i2c_scl", desc: "Connect port i2c_scl from port group i2c0 to this pad." }
                      { value: "2", name: "port_i2c0_i2c_sda", desc: "Connect port i2c_sda from port group i2c0 to this pad." }
                      { value: "3", name: "port_i2c1_i2c_scl", desc: "Connect port i2c_scl from port group i2c1 to this pad." }
                      { value: "4", name: "port_i2c1_i2c_sda", desc: "Connect port i2c_sda from port group i2c1 to this pad." }
                      { value: "5", name: "port_i2c2_i2c_scl", desc: "Connect port i2c_scl from port group i2c2 to this pad." }
                      { value: "6", name: "port_i2c2_i2c_sda", desc: "Connect port i2c_sda from port group i2c2 to this pad." }
                      { value: "7", name: "port_spi0_spi_cs", desc: "Connect port spi_cs from port group spi0 to this pad." }
                      { value: "8", name: "port_spi0_spi_miso", desc: "Connect port spi_miso from port group spi0 to this pad." }
                      { value: "9", name: "port_spi0_spi_mosi", desc: "Connect port spi_mosi from port group spi0 to this pad." }
                      { value: "10", name: "port_spi0_spi_sck", desc: "Connect port spi_sck from port group spi0 to this pad." }
                      { value: "11", name: "port_spi1_spi_cs", desc: "Connect port spi_cs from port group spi1 to this pad." }
                      { value: "12", name: "port_spi1_spi_miso", desc: "Connect port spi_miso from port group spi1 to this pad." }
                      { value: "13", name: "port_spi1_spi_mosi", desc: "Connect port spi_mosi from port group spi1 to this pad." }
                      { value: "14", name: "port_spi1_spi_sck", desc: "Connect port spi_sck from port group spi1 to this pad." }
                      { value: "15", name: "port_spi1_cs1_spi1_cs1", desc: "Connect port spi1_cs1 from port group spi1_cs1 to this pad." }
                  ]
              }
          ]
      }

      {
          name: PAD_IO_A_10_CFG
          desc: '''
            Pad signal configuration.
          '''
          swaccess: "rw"
          fields: [
            {
                bits: "0"
                name: chip2pad
                desc: '''
                     The signal that connects to the pads TX driver
                '''
                swaccess: "rw"
                hwaccess: "hro"
                resval: "0"
            },
            {
                bits: "1"
                name: oen
                desc: '''
                     Output enable signal, active low
                '''
                swaccess: "rw"
                hwaccess: "hro"
                resval: "1"
            },
          ]
      }

       {
          name: PAD_IO_A_10_MUX_SEL
          desc: '''
              Pad signal port multiplex selection for pad pad_io_a_10. The programmed value defines which port
              is connected to the pad.
          '''
          swaccess: "rw"
          hwaccess: "hro"
          resval: 0
          fields: [
              {
                  bits: "3:0"
                  enum: [
                      { value: "0", name: "register", desc: "Connects the Pad to the internal configuration register."}
                      { value: "1", name: "port_i2c0_i2c_scl", desc: "Connect port i2c_scl from port group i2c0 to this pad." }
                      { value: "2", name: "port_i2c0_i2c_sda", desc: "Connect port i2c_sda from port group i2c0 to this pad." }
                      { value: "3", name: "port_i2c1_i2c_scl", desc: "Connect port i2c_scl from port group i2c1 to this pad." }
                      { value: "4", name: "port_i2c1_i2c_sda", desc: "Connect port i2c_sda from port group i2c1 to this pad." }
                      { value: "5", name: "port_i2c2_i2c_scl", desc: "Connect port i2c_scl from port group i2c2 to this pad." }
                      { value: "6", name: "port_i2c2_i2c_sda", desc: "Connect port i2c_sda from port group i2c2 to this pad." }
                      { value: "7", name: "port_spi0_spi_cs", desc: "Connect port spi_cs from port group spi0 to this pad." }
                      { value: "8", name: "port_spi0_spi_miso", desc: "Connect port spi_miso from port group spi0 to this pad." }
                      { value: "9", name: "port_spi0_spi_mosi", desc: "Connect port spi_mosi from port group spi0 to this pad." }
                      { value: "10", name: "port_spi0_spi_sck", desc: "Connect port spi_sck from port group spi0 to this pad." }
                      { value: "11", name: "port_spi1_spi_cs", desc: "Connect port spi_cs from port group spi1 to this pad." }
                      { value: "12", name: "port_spi1_spi_miso", desc: "Connect port spi_miso from port group spi1 to this pad." }
                      { value: "13", name: "port_spi1_spi_mosi", desc: "Connect port spi_mosi from port group spi1 to this pad." }
                      { value: "14", name: "port_spi1_spi_sck", desc: "Connect port spi_sck from port group spi1 to this pad." }
                      { value: "15", name: "port_spi1_cs1_spi1_cs1", desc: "Connect port spi1_cs1 from port group spi1_cs1 to this pad." }
                  ]
              }
          ]
      }

      {
          name: PAD_IO_A_11_CFG
          desc: '''
            Pad signal configuration.
          '''
          swaccess: "rw"
          fields: [
            {
                bits: "0"
                name: chip2pad
                desc: '''
                     The signal that connects to the pads TX driver
                '''
                swaccess: "rw"
                hwaccess: "hro"
                resval: "0"
            },
            {
                bits: "1"
                name: oen
                desc: '''
                     Output enable signal, active low
                '''
                swaccess: "rw"
                hwaccess: "hro"
                resval: "1"
            },
          ]
      }

       {
          name: PAD_IO_A_11_MUX_SEL
          desc: '''
              Pad signal port multiplex selection for pad pad_io_a_11. The programmed value defines which port
              is connected to the pad.
          '''
          swaccess: "rw"
          hwaccess: "hro"
          resval: 0
          fields: [
              {
                  bits: "3:0"
                  enum: [
                      { value: "0", name: "register", desc: "Connects the Pad to the internal configuration register."}
                      { value: "1", name: "port_i2c0_i2c_scl", desc: "Connect port i2c_scl from port group i2c0 to this pad." }
                      { value: "2", name: "port_i2c0_i2c_sda", desc: "Connect port i2c_sda from port group i2c0 to this pad." }
                      { value: "3", name: "port_i2c1_i2c_scl", desc: "Connect port i2c_scl from port group i2c1 to this pad." }
                      { value: "4", name: "port_i2c1_i2c_sda", desc: "Connect port i2c_sda from port group i2c1 to this pad." }
                      { value: "5", name: "port_i2c2_i2c_scl", desc: "Connect port i2c_scl from port group i2c2 to this pad." }
                      { value: "6", name: "port_i2c2_i2c_sda", desc: "Connect port i2c_sda from port group i2c2 to this pad." }
                      { value: "7", name: "port_spi0_spi_cs", desc: "Connect port spi_cs from port group spi0 to this pad." }
                      { value: "8", name: "port_spi0_spi_miso", desc: "Connect port spi_miso from port group spi0 to this pad." }
                      { value: "9", name: "port_spi0_spi_mosi", desc: "Connect port spi_mosi from port group spi0 to this pad." }
                      { value: "10", name: "port_spi0_spi_sck", desc: "Connect port spi_sck from port group spi0 to this pad." }
                      { value: "11", name: "port_spi1_spi_cs", desc: "Connect port spi_cs from port group spi1 to this pad." }
                      { value: "12", name: "port_spi1_spi_miso", desc: "Connect port spi_miso from port group spi1 to this pad." }
                      { value: "13", name: "port_spi1_spi_mosi", desc: "Connect port spi_mosi from port group spi1 to this pad." }
                      { value: "14", name: "port_spi1_spi_sck", desc: "Connect port spi_sck from port group spi1 to this pad." }
                      { value: "15", name: "port_spi1_cs1_spi1_cs1", desc: "Connect port spi1_cs1 from port group spi1_cs1 to this pad." }
                  ]
              }
          ]
      }

      {
          name: PAD_IO_A_12_CFG
          desc: '''
            Pad signal configuration.
          '''
          swaccess: "rw"
          fields: [
            {
                bits: "0"
                name: chip2pad
                desc: '''
                     The signal that connects to the pads TX driver
                '''
                swaccess: "rw"
                hwaccess: "hro"
                resval: "0"
            },
            {
                bits: "1"
                name: oen
                desc: '''
                     Output enable signal, active low
                '''
                swaccess: "rw"
                hwaccess: "hro"
                resval: "1"
            },
          ]
      }

       {
          name: PAD_IO_A_12_MUX_SEL
          desc: '''
              Pad signal port multiplex selection for pad pad_io_a_12. The programmed value defines which port
              is connected to the pad.
          '''
          swaccess: "rw"
          hwaccess: "hro"
          resval: 0
          fields: [
              {
                  bits: "3:0"
                  enum: [
                      { value: "0", name: "register", desc: "Connects the Pad to the internal configuration register."}
                      { value: "1", name: "port_i2c0_i2c_scl", desc: "Connect port i2c_scl from port group i2c0 to this pad." }
                      { value: "2", name: "port_i2c0_i2c_sda", desc: "Connect port i2c_sda from port group i2c0 to this pad." }
                      { value: "3", name: "port_i2c1_i2c_scl", desc: "Connect port i2c_scl from port group i2c1 to this pad." }
                      { value: "4", name: "port_i2c1_i2c_sda", desc: "Connect port i2c_sda from port group i2c1 to this pad." }
                      { value: "5", name: "port_i2c2_i2c_scl", desc: "Connect port i2c_scl from port group i2c2 to this pad." }
                      { value: "6", name: "port_i2c2_i2c_sda", desc: "Connect port i2c_sda from port group i2c2 to this pad." }
                      { value: "7", name: "port_spi0_spi_cs", desc: "Connect port spi_cs from port group spi0 to this pad." }
                      { value: "8", name: "port_spi0_spi_miso", desc: "Connect port spi_miso from port group spi0 to this pad." }
                      { value: "9", name: "port_spi0_spi_mosi", desc: "Connect port spi_mosi from port group spi0 to this pad." }
                      { value: "10", name: "port_spi0_spi_sck", desc: "Connect port spi_sck from port group spi0 to this pad." }
                      { value: "11", name: "port_spi1_spi_cs", desc: "Connect port spi_cs from port group spi1 to this pad." }
                      { value: "12", name: "port_spi1_spi_miso", desc: "Connect port spi_miso from port group spi1 to this pad." }
                      { value: "13", name: "port_spi1_spi_mosi", desc: "Connect port spi_mosi from port group spi1 to this pad." }
                      { value: "14", name: "port_spi1_spi_sck", desc: "Connect port spi_sck from port group spi1 to this pad." }
                      { value: "15", name: "port_spi1_cs1_spi1_cs1", desc: "Connect port spi1_cs1 from port group spi1_cs1 to this pad." }
                  ]
              }
          ]
      }

      {
          name: PAD_IO_A_13_CFG
          desc: '''
            Pad signal configuration.
          '''
          swaccess: "rw"
          fields: [
            {
                bits: "0"
                name: chip2pad
                desc: '''
                     The signal that connects to the pads TX driver
                '''
                swaccess: "rw"
                hwaccess: "hro"
                resval: "0"
            },
            {
                bits: "1"
                name: oen
                desc: '''
                     Output enable signal, active low
                '''
                swaccess: "rw"
                hwaccess: "hro"
                resval: "1"
            },
          ]
      }

       {
          name: PAD_IO_A_13_MUX_SEL
          desc: '''
              Pad signal port multiplex selection for pad pad_io_a_13. The programmed value defines which port
              is connected to the pad.
          '''
          swaccess: "rw"
          hwaccess: "hro"
          resval: 0
          fields: [
              {
                  bits: "3:0"
                  enum: [
                      { value: "0", name: "register", desc: "Connects the Pad to the internal configuration register."}
                      { value: "1", name: "port_i2c0_i2c_scl", desc: "Connect port i2c_scl from port group i2c0 to this pad." }
                      { value: "2", name: "port_i2c0_i2c_sda", desc: "Connect port i2c_sda from port group i2c0 to this pad." }
                      { value: "3", name: "port_i2c1_i2c_scl", desc: "Connect port i2c_scl from port group i2c1 to this pad." }
                      { value: "4", name: "port_i2c1_i2c_sda", desc: "Connect port i2c_sda from port group i2c1 to this pad." }
                      { value: "5", name: "port_i2c2_i2c_scl", desc: "Connect port i2c_scl from port group i2c2 to this pad." }
                      { value: "6", name: "port_i2c2_i2c_sda", desc: "Connect port i2c_sda from port group i2c2 to this pad." }
                      { value: "7", name: "port_spi0_spi_cs", desc: "Connect port spi_cs from port group spi0 to this pad." }
                      { value: "8", name: "port_spi0_spi_miso", desc: "Connect port spi_miso from port group spi0 to this pad." }
                      { value: "9", name: "port_spi0_spi_mosi", desc: "Connect port spi_mosi from port group spi0 to this pad." }
                      { value: "10", name: "port_spi0_spi_sck", desc: "Connect port spi_sck from port group spi0 to this pad." }
                      { value: "11", name: "port_spi1_spi_cs", desc: "Connect port spi_cs from port group spi1 to this pad." }
                      { value: "12", name: "port_spi1_spi_miso", desc: "Connect port spi_miso from port group spi1 to this pad." }
                      { value: "13", name: "port_spi1_spi_mosi", desc: "Connect port spi_mosi from port group spi1 to this pad." }
                      { value: "14", name: "port_spi1_spi_sck", desc: "Connect port spi_sck from port group spi1 to this pad." }
                      { value: "15", name: "port_spi1_cs1_spi1_cs1", desc: "Connect port spi1_cs1 from port group spi1_cs1 to this pad." }
                  ]
              }
          ]
      }

      {
          name: PAD_IO_A_14_CFG
          desc: '''
            Pad signal configuration.
          '''
          swaccess: "rw"
          fields: [
            {
                bits: "0"
                name: chip2pad
                desc: '''
                     The signal that connects to the pads TX driver
                '''
                swaccess: "rw"
                hwaccess: "hro"
                resval: "0"
            },
            {
                bits: "1"
                name: oen
                desc: '''
                     Output enable signal, active low
                '''
                swaccess: "rw"
                hwaccess: "hro"
                resval: "1"
            },
          ]
      }

       {
          name: PAD_IO_A_14_MUX_SEL
          desc: '''
              Pad signal port multiplex selection for pad pad_io_a_14. The programmed value defines which port
              is connected to the pad.
          '''
          swaccess: "rw"
          hwaccess: "hro"
          resval: 0
          fields: [
              {
                  bits: "3:0"
                  enum: [
                      { value: "0", name: "register", desc: "Connects the Pad to the internal configuration register."}
                      { value: "1", name: "port_i2c0_i2c_scl", desc: "Connect port i2c_scl from port group i2c0 to this pad." }
                      { value: "2", name: "port_i2c0_i2c_sda", desc: "Connect port i2c_sda from port group i2c0 to this pad." }
                      { value: "3", name: "port_i2c1_i2c_scl", desc: "Connect port i2c_scl from port group i2c1 to this pad." }
                      { value: "4", name: "port_i2c1_i2c_sda", desc: "Connect port i2c_sda from port group i2c1 to this pad." }
                      { value: "5", name: "port_i2c2_i2c_scl", desc: "Connect port i2c_scl from port group i2c2 to this pad." }
                      { value: "6", name: "port_i2c2_i2c_sda", desc: "Connect port i2c_sda from port group i2c2 to this pad." }
                      { value: "7", name: "port_spi0_spi_cs", desc: "Connect port spi_cs from port group spi0 to this pad." }
                      { value: "8", name: "port_spi0_spi_miso", desc: "Connect port spi_miso from port group spi0 to this pad." }
                      { value: "9", name: "port_spi0_spi_mosi", desc: "Connect port spi_mosi from port group spi0 to this pad." }
                      { value: "10", name: "port_spi0_spi_sck", desc: "Connect port spi_sck from port group spi0 to this pad." }
                      { value: "11", name: "port_spi1_spi_cs", desc: "Connect port spi_cs from port group spi1 to this pad." }
                      { value: "12", name: "port_spi1_spi_miso", desc: "Connect port spi_miso from port group spi1 to this pad." }
                      { value: "13", name: "port_spi1_spi_mosi", desc: "Connect port spi_mosi from port group spi1 to this pad." }
                      { value: "14", name: "port_spi1_spi_sck", desc: "Connect port spi_sck from port group spi1 to this pad." }
                      { value: "15", name: "port_spi1_cs1_spi1_cs1", desc: "Connect port spi1_cs1 from port group spi1_cs1 to this pad." }
                  ]
              }
          ]
      }

      {
          name: PAD_IO_B_00_CFG
          desc: '''
            Pad signal configuration.
          '''
          swaccess: "rw"
          fields: [
            {
                bits: "0"
                name: chip2pad
                desc: '''
                     The signal that connects to the pads TX driver
                '''
                swaccess: "rw"
                hwaccess: "hro"
                resval: "0"
            },
            {
                bits: "1"
                name: oen
                desc: '''
                     Output enable signal, active low
                '''
                swaccess: "rw"
                hwaccess: "hro"
                resval: "1"
            },
          ]
      }

       {
          name: PAD_IO_B_00_MUX_SEL
          desc: '''
              Pad signal port multiplex selection for pad pad_io_b_00. The programmed value defines which port
              is connected to the pad.
          '''
          swaccess: "rw"
          hwaccess: "hro"
          resval: 0
          fields: [
              {
                  bits: "4:0"
                  enum: [
                      { value: "0", name: "register", desc: "Connects the Pad to the internal configuration register."}
                      { value: "1", name: "port_spi2_spi_cs", desc: "Connect port spi_cs from port group spi2 to this pad." }
                      { value: "2", name: "port_spi2_spi_miso", desc: "Connect port spi_miso from port group spi2 to this pad." }
                      { value: "3", name: "port_spi2_spi_mosi", desc: "Connect port spi_mosi from port group spi2 to this pad." }
                      { value: "4", name: "port_spi2_spi_sck", desc: "Connect port spi_sck from port group spi2 to this pad." }
                      { value: "5", name: "port_spi3_spi_cs", desc: "Connect port spi_cs from port group spi3 to this pad." }
                      { value: "6", name: "port_spi3_spi_miso", desc: "Connect port spi_miso from port group spi3 to this pad." }
                      { value: "7", name: "port_spi3_spi_mosi", desc: "Connect port spi_mosi from port group spi3 to this pad." }
                      { value: "8", name: "port_spi3_spi_sck", desc: "Connect port spi_sck from port group spi3 to this pad." }
                      { value: "9", name: "port_spi4_spi_cs", desc: "Connect port spi_cs from port group spi4 to this pad." }
                      { value: "10", name: "port_spi4_spi_miso", desc: "Connect port spi_miso from port group spi4 to this pad." }
                      { value: "11", name: "port_spi4_spi_mosi", desc: "Connect port spi_mosi from port group spi4 to this pad." }
                      { value: "12", name: "port_spi4_spi_sck", desc: "Connect port spi_sck from port group spi4 to this pad." }
                      { value: "13", name: "port_spi5_spi_cs", desc: "Connect port spi_cs from port group spi5 to this pad." }
                      { value: "14", name: "port_spi5_spi_miso", desc: "Connect port spi_miso from port group spi5 to this pad." }
                      { value: "15", name: "port_spi5_spi_mosi", desc: "Connect port spi_mosi from port group spi5 to this pad." }
                      { value: "16", name: "port_spi5_spi_sck", desc: "Connect port spi_sck from port group spi5 to this pad." }
                      { value: "17", name: "port_spi6_spi_cs", desc: "Connect port spi_cs from port group spi6 to this pad." }
                      { value: "18", name: "port_spi6_spi_miso", desc: "Connect port spi_miso from port group spi6 to this pad." }
                      { value: "19", name: "port_spi6_spi_mosi", desc: "Connect port spi_mosi from port group spi6 to this pad." }
                      { value: "20", name: "port_spi6_spi_sck", desc: "Connect port spi_sck from port group spi6 to this pad." }
                  ]
              }
          ]
      }

      {
          name: PAD_IO_B_01_CFG
          desc: '''
            Pad signal configuration.
          '''
          swaccess: "rw"
          fields: [
            {
                bits: "0"
                name: chip2pad
                desc: '''
                     The signal that connects to the pads TX driver
                '''
                swaccess: "rw"
                hwaccess: "hro"
                resval: "0"
            },
            {
                bits: "1"
                name: oen
                desc: '''
                     Output enable signal, active low
                '''
                swaccess: "rw"
                hwaccess: "hro"
                resval: "1"
            },
          ]
      }

       {
          name: PAD_IO_B_01_MUX_SEL
          desc: '''
              Pad signal port multiplex selection for pad pad_io_b_01. The programmed value defines which port
              is connected to the pad.
          '''
          swaccess: "rw"
          hwaccess: "hro"
          resval: 0
          fields: [
              {
                  bits: "4:0"
                  enum: [
                      { value: "0", name: "register", desc: "Connects the Pad to the internal configuration register."}
                      { value: "1", name: "port_spi2_spi_cs", desc: "Connect port spi_cs from port group spi2 to this pad." }
                      { value: "2", name: "port_spi2_spi_miso", desc: "Connect port spi_miso from port group spi2 to this pad." }
                      { value: "3", name: "port_spi2_spi_mosi", desc: "Connect port spi_mosi from port group spi2 to this pad." }
                      { value: "4", name: "port_spi2_spi_sck", desc: "Connect port spi_sck from port group spi2 to this pad." }
                      { value: "5", name: "port_spi3_spi_cs", desc: "Connect port spi_cs from port group spi3 to this pad." }
                      { value: "6", name: "port_spi3_spi_miso", desc: "Connect port spi_miso from port group spi3 to this pad." }
                      { value: "7", name: "port_spi3_spi_mosi", desc: "Connect port spi_mosi from port group spi3 to this pad." }
                      { value: "8", name: "port_spi3_spi_sck", desc: "Connect port spi_sck from port group spi3 to this pad." }
                      { value: "9", name: "port_spi4_spi_cs", desc: "Connect port spi_cs from port group spi4 to this pad." }
                      { value: "10", name: "port_spi4_spi_miso", desc: "Connect port spi_miso from port group spi4 to this pad." }
                      { value: "11", name: "port_spi4_spi_mosi", desc: "Connect port spi_mosi from port group spi4 to this pad." }
                      { value: "12", name: "port_spi4_spi_sck", desc: "Connect port spi_sck from port group spi4 to this pad." }
                      { value: "13", name: "port_spi5_spi_cs", desc: "Connect port spi_cs from port group spi5 to this pad." }
                      { value: "14", name: "port_spi5_spi_miso", desc: "Connect port spi_miso from port group spi5 to this pad." }
                      { value: "15", name: "port_spi5_spi_mosi", desc: "Connect port spi_mosi from port group spi5 to this pad." }
                      { value: "16", name: "port_spi5_spi_sck", desc: "Connect port spi_sck from port group spi5 to this pad." }
                      { value: "17", name: "port_spi6_spi_cs", desc: "Connect port spi_cs from port group spi6 to this pad." }
                      { value: "18", name: "port_spi6_spi_miso", desc: "Connect port spi_miso from port group spi6 to this pad." }
                      { value: "19", name: "port_spi6_spi_mosi", desc: "Connect port spi_mosi from port group spi6 to this pad." }
                      { value: "20", name: "port_spi6_spi_sck", desc: "Connect port spi_sck from port group spi6 to this pad." }
                  ]
              }
          ]
      }

      {
          name: PAD_IO_B_02_CFG
          desc: '''
            Pad signal configuration.
          '''
          swaccess: "rw"
          fields: [
            {
                bits: "0"
                name: chip2pad
                desc: '''
                     The signal that connects to the pads TX driver
                '''
                swaccess: "rw"
                hwaccess: "hro"
                resval: "0"
            },
            {
                bits: "1"
                name: oen
                desc: '''
                     Output enable signal, active low
                '''
                swaccess: "rw"
                hwaccess: "hro"
                resval: "1"
            },
          ]
      }

       {
          name: PAD_IO_B_02_MUX_SEL
          desc: '''
              Pad signal port multiplex selection for pad pad_io_b_02. The programmed value defines which port
              is connected to the pad.
          '''
          swaccess: "rw"
          hwaccess: "hro"
          resval: 0
          fields: [
              {
                  bits: "4:0"
                  enum: [
                      { value: "0", name: "register", desc: "Connects the Pad to the internal configuration register."}
                      { value: "1", name: "port_spi2_spi_cs", desc: "Connect port spi_cs from port group spi2 to this pad." }
                      { value: "2", name: "port_spi2_spi_miso", desc: "Connect port spi_miso from port group spi2 to this pad." }
                      { value: "3", name: "port_spi2_spi_mosi", desc: "Connect port spi_mosi from port group spi2 to this pad." }
                      { value: "4", name: "port_spi2_spi_sck", desc: "Connect port spi_sck from port group spi2 to this pad." }
                      { value: "5", name: "port_spi3_spi_cs", desc: "Connect port spi_cs from port group spi3 to this pad." }
                      { value: "6", name: "port_spi3_spi_miso", desc: "Connect port spi_miso from port group spi3 to this pad." }
                      { value: "7", name: "port_spi3_spi_mosi", desc: "Connect port spi_mosi from port group spi3 to this pad." }
                      { value: "8", name: "port_spi3_spi_sck", desc: "Connect port spi_sck from port group spi3 to this pad." }
                      { value: "9", name: "port_spi4_spi_cs", desc: "Connect port spi_cs from port group spi4 to this pad." }
                      { value: "10", name: "port_spi4_spi_miso", desc: "Connect port spi_miso from port group spi4 to this pad." }
                      { value: "11", name: "port_spi4_spi_mosi", desc: "Connect port spi_mosi from port group spi4 to this pad." }
                      { value: "12", name: "port_spi4_spi_sck", desc: "Connect port spi_sck from port group spi4 to this pad." }
                      { value: "13", name: "port_spi5_spi_cs", desc: "Connect port spi_cs from port group spi5 to this pad." }
                      { value: "14", name: "port_spi5_spi_miso", desc: "Connect port spi_miso from port group spi5 to this pad." }
                      { value: "15", name: "port_spi5_spi_mosi", desc: "Connect port spi_mosi from port group spi5 to this pad." }
                      { value: "16", name: "port_spi5_spi_sck", desc: "Connect port spi_sck from port group spi5 to this pad." }
                      { value: "17", name: "port_spi6_spi_cs", desc: "Connect port spi_cs from port group spi6 to this pad." }
                      { value: "18", name: "port_spi6_spi_miso", desc: "Connect port spi_miso from port group spi6 to this pad." }
                      { value: "19", name: "port_spi6_spi_mosi", desc: "Connect port spi_mosi from port group spi6 to this pad." }
                      { value: "20", name: "port_spi6_spi_sck", desc: "Connect port spi_sck from port group spi6 to this pad." }
                  ]
              }
          ]
      }

      {
          name: PAD_IO_B_03_CFG
          desc: '''
            Pad signal configuration.
          '''
          swaccess: "rw"
          fields: [
            {
                bits: "0"
                name: chip2pad
                desc: '''
                     The signal that connects to the pads TX driver
                '''
                swaccess: "rw"
                hwaccess: "hro"
                resval: "0"
            },
            {
                bits: "1"
                name: oen
                desc: '''
                     Output enable signal, active low
                '''
                swaccess: "rw"
                hwaccess: "hro"
                resval: "1"
            },
          ]
      }

       {
          name: PAD_IO_B_03_MUX_SEL
          desc: '''
              Pad signal port multiplex selection for pad pad_io_b_03. The programmed value defines which port
              is connected to the pad.
          '''
          swaccess: "rw"
          hwaccess: "hro"
          resval: 0
          fields: [
              {
                  bits: "4:0"
                  enum: [
                      { value: "0", name: "register", desc: "Connects the Pad to the internal configuration register."}
                      { value: "1", name: "port_spi2_spi_cs", desc: "Connect port spi_cs from port group spi2 to this pad." }
                      { value: "2", name: "port_spi2_spi_miso", desc: "Connect port spi_miso from port group spi2 to this pad." }
                      { value: "3", name: "port_spi2_spi_mosi", desc: "Connect port spi_mosi from port group spi2 to this pad." }
                      { value: "4", name: "port_spi2_spi_sck", desc: "Connect port spi_sck from port group spi2 to this pad." }
                      { value: "5", name: "port_spi3_spi_cs", desc: "Connect port spi_cs from port group spi3 to this pad." }
                      { value: "6", name: "port_spi3_spi_miso", desc: "Connect port spi_miso from port group spi3 to this pad." }
                      { value: "7", name: "port_spi3_spi_mosi", desc: "Connect port spi_mosi from port group spi3 to this pad." }
                      { value: "8", name: "port_spi3_spi_sck", desc: "Connect port spi_sck from port group spi3 to this pad." }
                      { value: "9", name: "port_spi4_spi_cs", desc: "Connect port spi_cs from port group spi4 to this pad." }
                      { value: "10", name: "port_spi4_spi_miso", desc: "Connect port spi_miso from port group spi4 to this pad." }
                      { value: "11", name: "port_spi4_spi_mosi", desc: "Connect port spi_mosi from port group spi4 to this pad." }
                      { value: "12", name: "port_spi4_spi_sck", desc: "Connect port spi_sck from port group spi4 to this pad." }
                      { value: "13", name: "port_spi5_spi_cs", desc: "Connect port spi_cs from port group spi5 to this pad." }
                      { value: "14", name: "port_spi5_spi_miso", desc: "Connect port spi_miso from port group spi5 to this pad." }
                      { value: "15", name: "port_spi5_spi_mosi", desc: "Connect port spi_mosi from port group spi5 to this pad." }
                      { value: "16", name: "port_spi5_spi_sck", desc: "Connect port spi_sck from port group spi5 to this pad." }
                      { value: "17", name: "port_spi6_spi_cs", desc: "Connect port spi_cs from port group spi6 to this pad." }
                      { value: "18", name: "port_spi6_spi_miso", desc: "Connect port spi_miso from port group spi6 to this pad." }
                      { value: "19", name: "port_spi6_spi_mosi", desc: "Connect port spi_mosi from port group spi6 to this pad." }
                      { value: "20", name: "port_spi6_spi_sck", desc: "Connect port spi_sck from port group spi6 to this pad." }
                  ]
              }
          ]
      }

      {
          name: PAD_IO_B_04_CFG
          desc: '''
            Pad signal configuration.
          '''
          swaccess: "rw"
          fields: [
            {
                bits: "0"
                name: chip2pad
                desc: '''
                     The signal that connects to the pads TX driver
                '''
                swaccess: "rw"
                hwaccess: "hro"
                resval: "0"
            },
            {
                bits: "1"
                name: oen
                desc: '''
                     Output enable signal, active low
                '''
                swaccess: "rw"
                hwaccess: "hro"
                resval: "1"
            },
          ]
      }

       {
          name: PAD_IO_B_04_MUX_SEL
          desc: '''
              Pad signal port multiplex selection for pad pad_io_b_04. The programmed value defines which port
              is connected to the pad.
          '''
          swaccess: "rw"
          hwaccess: "hro"
          resval: 0
          fields: [
              {
                  bits: "4:0"
                  enum: [
                      { value: "0", name: "register", desc: "Connects the Pad to the internal configuration register."}
                      { value: "1", name: "port_spi2_spi_cs", desc: "Connect port spi_cs from port group spi2 to this pad." }
                      { value: "2", name: "port_spi2_spi_miso", desc: "Connect port spi_miso from port group spi2 to this pad." }
                      { value: "3", name: "port_spi2_spi_mosi", desc: "Connect port spi_mosi from port group spi2 to this pad." }
                      { value: "4", name: "port_spi2_spi_sck", desc: "Connect port spi_sck from port group spi2 to this pad." }
                      { value: "5", name: "port_spi3_spi_cs", desc: "Connect port spi_cs from port group spi3 to this pad." }
                      { value: "6", name: "port_spi3_spi_miso", desc: "Connect port spi_miso from port group spi3 to this pad." }
                      { value: "7", name: "port_spi3_spi_mosi", desc: "Connect port spi_mosi from port group spi3 to this pad." }
                      { value: "8", name: "port_spi3_spi_sck", desc: "Connect port spi_sck from port group spi3 to this pad." }
                      { value: "9", name: "port_spi4_spi_cs", desc: "Connect port spi_cs from port group spi4 to this pad." }
                      { value: "10", name: "port_spi4_spi_miso", desc: "Connect port spi_miso from port group spi4 to this pad." }
                      { value: "11", name: "port_spi4_spi_mosi", desc: "Connect port spi_mosi from port group spi4 to this pad." }
                      { value: "12", name: "port_spi4_spi_sck", desc: "Connect port spi_sck from port group spi4 to this pad." }
                      { value: "13", name: "port_spi5_spi_cs", desc: "Connect port spi_cs from port group spi5 to this pad." }
                      { value: "14", name: "port_spi5_spi_miso", desc: "Connect port spi_miso from port group spi5 to this pad." }
                      { value: "15", name: "port_spi5_spi_mosi", desc: "Connect port spi_mosi from port group spi5 to this pad." }
                      { value: "16", name: "port_spi5_spi_sck", desc: "Connect port spi_sck from port group spi5 to this pad." }
                      { value: "17", name: "port_spi6_spi_cs", desc: "Connect port spi_cs from port group spi6 to this pad." }
                      { value: "18", name: "port_spi6_spi_miso", desc: "Connect port spi_miso from port group spi6 to this pad." }
                      { value: "19", name: "port_spi6_spi_mosi", desc: "Connect port spi_mosi from port group spi6 to this pad." }
                      { value: "20", name: "port_spi6_spi_sck", desc: "Connect port spi_sck from port group spi6 to this pad." }
                  ]
              }
          ]
      }

      {
          name: PAD_IO_B_05_CFG
          desc: '''
            Pad signal configuration.
          '''
          swaccess: "rw"
          fields: [
            {
                bits: "0"
                name: chip2pad
                desc: '''
                     The signal that connects to the pads TX driver
                '''
                swaccess: "rw"
                hwaccess: "hro"
                resval: "0"
            },
            {
                bits: "1"
                name: oen
                desc: '''
                     Output enable signal, active low
                '''
                swaccess: "rw"
                hwaccess: "hro"
                resval: "1"
            },
          ]
      }

       {
          name: PAD_IO_B_05_MUX_SEL
          desc: '''
              Pad signal port multiplex selection for pad pad_io_b_05. The programmed value defines which port
              is connected to the pad.
          '''
          swaccess: "rw"
          hwaccess: "hro"
          resval: 0
          fields: [
              {
                  bits: "4:0"
                  enum: [
                      { value: "0", name: "register", desc: "Connects the Pad to the internal configuration register."}
                      { value: "1", name: "port_spi2_spi_cs", desc: "Connect port spi_cs from port group spi2 to this pad." }
                      { value: "2", name: "port_spi2_spi_miso", desc: "Connect port spi_miso from port group spi2 to this pad." }
                      { value: "3", name: "port_spi2_spi_mosi", desc: "Connect port spi_mosi from port group spi2 to this pad." }
                      { value: "4", name: "port_spi2_spi_sck", desc: "Connect port spi_sck from port group spi2 to this pad." }
                      { value: "5", name: "port_spi3_spi_cs", desc: "Connect port spi_cs from port group spi3 to this pad." }
                      { value: "6", name: "port_spi3_spi_miso", desc: "Connect port spi_miso from port group spi3 to this pad." }
                      { value: "7", name: "port_spi3_spi_mosi", desc: "Connect port spi_mosi from port group spi3 to this pad." }
                      { value: "8", name: "port_spi3_spi_sck", desc: "Connect port spi_sck from port group spi3 to this pad." }
                      { value: "9", name: "port_spi4_spi_cs", desc: "Connect port spi_cs from port group spi4 to this pad." }
                      { value: "10", name: "port_spi4_spi_miso", desc: "Connect port spi_miso from port group spi4 to this pad." }
                      { value: "11", name: "port_spi4_spi_mosi", desc: "Connect port spi_mosi from port group spi4 to this pad." }
                      { value: "12", name: "port_spi4_spi_sck", desc: "Connect port spi_sck from port group spi4 to this pad." }
                      { value: "13", name: "port_spi5_spi_cs", desc: "Connect port spi_cs from port group spi5 to this pad." }
                      { value: "14", name: "port_spi5_spi_miso", desc: "Connect port spi_miso from port group spi5 to this pad." }
                      { value: "15", name: "port_spi5_spi_mosi", desc: "Connect port spi_mosi from port group spi5 to this pad." }
                      { value: "16", name: "port_spi5_spi_sck", desc: "Connect port spi_sck from port group spi5 to this pad." }
                      { value: "17", name: "port_spi6_spi_cs", desc: "Connect port spi_cs from port group spi6 to this pad." }
                      { value: "18", name: "port_spi6_spi_miso", desc: "Connect port spi_miso from port group spi6 to this pad." }
                      { value: "19", name: "port_spi6_spi_mosi", desc: "Connect port spi_mosi from port group spi6 to this pad." }
                      { value: "20", name: "port_spi6_spi_sck", desc: "Connect port spi_sck from port group spi6 to this pad." }
                  ]
              }
          ]
      }

      {
          name: PAD_IO_B_06_CFG
          desc: '''
            Pad signal configuration.
          '''
          swaccess: "rw"
          fields: [
            {
                bits: "0"
                name: chip2pad
                desc: '''
                     The signal that connects to the pads TX driver
                '''
                swaccess: "rw"
                hwaccess: "hro"
                resval: "0"
            },
            {
                bits: "1"
                name: oen
                desc: '''
                     Output enable signal, active low
                '''
                swaccess: "rw"
                hwaccess: "hro"
                resval: "1"
            },
          ]
      }

       {
          name: PAD_IO_B_06_MUX_SEL
          desc: '''
              Pad signal port multiplex selection for pad pad_io_b_06. The programmed value defines which port
              is connected to the pad.
          '''
          swaccess: "rw"
          hwaccess: "hro"
          resval: 0
          fields: [
              {
                  bits: "4:0"
                  enum: [
                      { value: "0", name: "register", desc: "Connects the Pad to the internal configuration register."}
                      { value: "1", name: "port_spi2_spi_cs", desc: "Connect port spi_cs from port group spi2 to this pad." }
                      { value: "2", name: "port_spi2_spi_miso", desc: "Connect port spi_miso from port group spi2 to this pad." }
                      { value: "3", name: "port_spi2_spi_mosi", desc: "Connect port spi_mosi from port group spi2 to this pad." }
                      { value: "4", name: "port_spi2_spi_sck", desc: "Connect port spi_sck from port group spi2 to this pad." }
                      { value: "5", name: "port_spi3_spi_cs", desc: "Connect port spi_cs from port group spi3 to this pad." }
                      { value: "6", name: "port_spi3_spi_miso", desc: "Connect port spi_miso from port group spi3 to this pad." }
                      { value: "7", name: "port_spi3_spi_mosi", desc: "Connect port spi_mosi from port group spi3 to this pad." }
                      { value: "8", name: "port_spi3_spi_sck", desc: "Connect port spi_sck from port group spi3 to this pad." }
                      { value: "9", name: "port_spi4_spi_cs", desc: "Connect port spi_cs from port group spi4 to this pad." }
                      { value: "10", name: "port_spi4_spi_miso", desc: "Connect port spi_miso from port group spi4 to this pad." }
                      { value: "11", name: "port_spi4_spi_mosi", desc: "Connect port spi_mosi from port group spi4 to this pad." }
                      { value: "12", name: "port_spi4_spi_sck", desc: "Connect port spi_sck from port group spi4 to this pad." }
                      { value: "13", name: "port_spi5_spi_cs", desc: "Connect port spi_cs from port group spi5 to this pad." }
                      { value: "14", name: "port_spi5_spi_miso", desc: "Connect port spi_miso from port group spi5 to this pad." }
                      { value: "15", name: "port_spi5_spi_mosi", desc: "Connect port spi_mosi from port group spi5 to this pad." }
                      { value: "16", name: "port_spi5_spi_sck", desc: "Connect port spi_sck from port group spi5 to this pad." }
                      { value: "17", name: "port_spi6_spi_cs", desc: "Connect port spi_cs from port group spi6 to this pad." }
                      { value: "18", name: "port_spi6_spi_miso", desc: "Connect port spi_miso from port group spi6 to this pad." }
                      { value: "19", name: "port_spi6_spi_mosi", desc: "Connect port spi_mosi from port group spi6 to this pad." }
                      { value: "20", name: "port_spi6_spi_sck", desc: "Connect port spi_sck from port group spi6 to this pad." }
                  ]
              }
          ]
      }

      {
          name: PAD_IO_B_07_CFG
          desc: '''
            Pad signal configuration.
          '''
          swaccess: "rw"
          fields: [
            {
                bits: "0"
                name: chip2pad
                desc: '''
                     The signal that connects to the pads TX driver
                '''
                swaccess: "rw"
                hwaccess: "hro"
                resval: "0"
            },
            {
                bits: "1"
                name: oen
                desc: '''
                     Output enable signal, active low
                '''
                swaccess: "rw"
                hwaccess: "hro"
                resval: "1"
            },
          ]
      }

       {
          name: PAD_IO_B_07_MUX_SEL
          desc: '''
              Pad signal port multiplex selection for pad pad_io_b_07. The programmed value defines which port
              is connected to the pad.
          '''
          swaccess: "rw"
          hwaccess: "hro"
          resval: 0
          fields: [
              {
                  bits: "4:0"
                  enum: [
                      { value: "0", name: "register", desc: "Connects the Pad to the internal configuration register."}
                      { value: "1", name: "port_spi2_spi_cs", desc: "Connect port spi_cs from port group spi2 to this pad." }
                      { value: "2", name: "port_spi2_spi_miso", desc: "Connect port spi_miso from port group spi2 to this pad." }
                      { value: "3", name: "port_spi2_spi_mosi", desc: "Connect port spi_mosi from port group spi2 to this pad." }
                      { value: "4", name: "port_spi2_spi_sck", desc: "Connect port spi_sck from port group spi2 to this pad." }
                      { value: "5", name: "port_spi3_spi_cs", desc: "Connect port spi_cs from port group spi3 to this pad." }
                      { value: "6", name: "port_spi3_spi_miso", desc: "Connect port spi_miso from port group spi3 to this pad." }
                      { value: "7", name: "port_spi3_spi_mosi", desc: "Connect port spi_mosi from port group spi3 to this pad." }
                      { value: "8", name: "port_spi3_spi_sck", desc: "Connect port spi_sck from port group spi3 to this pad." }
                      { value: "9", name: "port_spi4_spi_cs", desc: "Connect port spi_cs from port group spi4 to this pad." }
                      { value: "10", name: "port_spi4_spi_miso", desc: "Connect port spi_miso from port group spi4 to this pad." }
                      { value: "11", name: "port_spi4_spi_mosi", desc: "Connect port spi_mosi from port group spi4 to this pad." }
                      { value: "12", name: "port_spi4_spi_sck", desc: "Connect port spi_sck from port group spi4 to this pad." }
                      { value: "13", name: "port_spi5_spi_cs", desc: "Connect port spi_cs from port group spi5 to this pad." }
                      { value: "14", name: "port_spi5_spi_miso", desc: "Connect port spi_miso from port group spi5 to this pad." }
                      { value: "15", name: "port_spi5_spi_mosi", desc: "Connect port spi_mosi from port group spi5 to this pad." }
                      { value: "16", name: "port_spi5_spi_sck", desc: "Connect port spi_sck from port group spi5 to this pad." }
                      { value: "17", name: "port_spi6_spi_cs", desc: "Connect port spi_cs from port group spi6 to this pad." }
                      { value: "18", name: "port_spi6_spi_miso", desc: "Connect port spi_miso from port group spi6 to this pad." }
                      { value: "19", name: "port_spi6_spi_mosi", desc: "Connect port spi_mosi from port group spi6 to this pad." }
                      { value: "20", name: "port_spi6_spi_sck", desc: "Connect port spi_sck from port group spi6 to this pad." }
                  ]
              }
          ]
      }

      {
          name: PAD_IO_B_08_CFG
          desc: '''
            Pad signal configuration.
          '''
          swaccess: "rw"
          fields: [
            {
                bits: "0"
                name: chip2pad
                desc: '''
                     The signal that connects to the pads TX driver
                '''
                swaccess: "rw"
                hwaccess: "hro"
                resval: "0"
            },
            {
                bits: "1"
                name: oen
                desc: '''
                     Output enable signal, active low
                '''
                swaccess: "rw"
                hwaccess: "hro"
                resval: "1"
            },
          ]
      }

       {
          name: PAD_IO_B_08_MUX_SEL
          desc: '''
              Pad signal port multiplex selection for pad pad_io_b_08. The programmed value defines which port
              is connected to the pad.
          '''
          swaccess: "rw"
          hwaccess: "hro"
          resval: 0
          fields: [
              {
                  bits: "4:0"
                  enum: [
                      { value: "0", name: "register", desc: "Connects the Pad to the internal configuration register."}
                      { value: "1", name: "port_spi2_spi_cs", desc: "Connect port spi_cs from port group spi2 to this pad." }
                      { value: "2", name: "port_spi2_spi_miso", desc: "Connect port spi_miso from port group spi2 to this pad." }
                      { value: "3", name: "port_spi2_spi_mosi", desc: "Connect port spi_mosi from port group spi2 to this pad." }
                      { value: "4", name: "port_spi2_spi_sck", desc: "Connect port spi_sck from port group spi2 to this pad." }
                      { value: "5", name: "port_spi3_spi_cs", desc: "Connect port spi_cs from port group spi3 to this pad." }
                      { value: "6", name: "port_spi3_spi_miso", desc: "Connect port spi_miso from port group spi3 to this pad." }
                      { value: "7", name: "port_spi3_spi_mosi", desc: "Connect port spi_mosi from port group spi3 to this pad." }
                      { value: "8", name: "port_spi3_spi_sck", desc: "Connect port spi_sck from port group spi3 to this pad." }
                      { value: "9", name: "port_spi4_spi_cs", desc: "Connect port spi_cs from port group spi4 to this pad." }
                      { value: "10", name: "port_spi4_spi_miso", desc: "Connect port spi_miso from port group spi4 to this pad." }
                      { value: "11", name: "port_spi4_spi_mosi", desc: "Connect port spi_mosi from port group spi4 to this pad." }
                      { value: "12", name: "port_spi4_spi_sck", desc: "Connect port spi_sck from port group spi4 to this pad." }
                      { value: "13", name: "port_spi5_spi_cs", desc: "Connect port spi_cs from port group spi5 to this pad." }
                      { value: "14", name: "port_spi5_spi_miso", desc: "Connect port spi_miso from port group spi5 to this pad." }
                      { value: "15", name: "port_spi5_spi_mosi", desc: "Connect port spi_mosi from port group spi5 to this pad." }
                      { value: "16", name: "port_spi5_spi_sck", desc: "Connect port spi_sck from port group spi5 to this pad." }
                      { value: "17", name: "port_spi6_spi_cs", desc: "Connect port spi_cs from port group spi6 to this pad." }
                      { value: "18", name: "port_spi6_spi_miso", desc: "Connect port spi_miso from port group spi6 to this pad." }
                      { value: "19", name: "port_spi6_spi_mosi", desc: "Connect port spi_mosi from port group spi6 to this pad." }
                      { value: "20", name: "port_spi6_spi_sck", desc: "Connect port spi_sck from port group spi6 to this pad." }
                  ]
              }
          ]
      }

      {
          name: PAD_IO_B_09_CFG
          desc: '''
            Pad signal configuration.
          '''
          swaccess: "rw"
          fields: [
            {
                bits: "0"
                name: chip2pad
                desc: '''
                     The signal that connects to the pads TX driver
                '''
                swaccess: "rw"
                hwaccess: "hro"
                resval: "0"
            },
            {
                bits: "1"
                name: oen
                desc: '''
                     Output enable signal, active low
                '''
                swaccess: "rw"
                hwaccess: "hro"
                resval: "1"
            },
          ]
      }

       {
          name: PAD_IO_B_09_MUX_SEL
          desc: '''
              Pad signal port multiplex selection for pad pad_io_b_09. The programmed value defines which port
              is connected to the pad.
          '''
          swaccess: "rw"
          hwaccess: "hro"
          resval: 0
          fields: [
              {
                  bits: "4:0"
                  enum: [
                      { value: "0", name: "register", desc: "Connects the Pad to the internal configuration register."}
                      { value: "1", name: "port_spi2_spi_cs", desc: "Connect port spi_cs from port group spi2 to this pad." }
                      { value: "2", name: "port_spi2_spi_miso", desc: "Connect port spi_miso from port group spi2 to this pad." }
                      { value: "3", name: "port_spi2_spi_mosi", desc: "Connect port spi_mosi from port group spi2 to this pad." }
                      { value: "4", name: "port_spi2_spi_sck", desc: "Connect port spi_sck from port group spi2 to this pad." }
                      { value: "5", name: "port_spi3_spi_cs", desc: "Connect port spi_cs from port group spi3 to this pad." }
                      { value: "6", name: "port_spi3_spi_miso", desc: "Connect port spi_miso from port group spi3 to this pad." }
                      { value: "7", name: "port_spi3_spi_mosi", desc: "Connect port spi_mosi from port group spi3 to this pad." }
                      { value: "8", name: "port_spi3_spi_sck", desc: "Connect port spi_sck from port group spi3 to this pad." }
                      { value: "9", name: "port_spi4_spi_cs", desc: "Connect port spi_cs from port group spi4 to this pad." }
                      { value: "10", name: "port_spi4_spi_miso", desc: "Connect port spi_miso from port group spi4 to this pad." }
                      { value: "11", name: "port_spi4_spi_mosi", desc: "Connect port spi_mosi from port group spi4 to this pad." }
                      { value: "12", name: "port_spi4_spi_sck", desc: "Connect port spi_sck from port group spi4 to this pad." }
                      { value: "13", name: "port_spi5_spi_cs", desc: "Connect port spi_cs from port group spi5 to this pad." }
                      { value: "14", name: "port_spi5_spi_miso", desc: "Connect port spi_miso from port group spi5 to this pad." }
                      { value: "15", name: "port_spi5_spi_mosi", desc: "Connect port spi_mosi from port group spi5 to this pad." }
                      { value: "16", name: "port_spi5_spi_sck", desc: "Connect port spi_sck from port group spi5 to this pad." }
                      { value: "17", name: "port_spi6_spi_cs", desc: "Connect port spi_cs from port group spi6 to this pad." }
                      { value: "18", name: "port_spi6_spi_miso", desc: "Connect port spi_miso from port group spi6 to this pad." }
                      { value: "19", name: "port_spi6_spi_mosi", desc: "Connect port spi_mosi from port group spi6 to this pad." }
                      { value: "20", name: "port_spi6_spi_sck", desc: "Connect port spi_sck from port group spi6 to this pad." }
                  ]
              }
          ]
      }

      {
          name: PAD_IO_B_10_CFG
          desc: '''
            Pad signal configuration.
          '''
          swaccess: "rw"
          fields: [
            {
                bits: "0"
                name: chip2pad
                desc: '''
                     The signal that connects to the pads TX driver
                '''
                swaccess: "rw"
                hwaccess: "hro"
                resval: "0"
            },
            {
                bits: "1"
                name: oen
                desc: '''
                     Output enable signal, active low
                '''
                swaccess: "rw"
                hwaccess: "hro"
                resval: "1"
            },
          ]
      }

       {
          name: PAD_IO_B_10_MUX_SEL
          desc: '''
              Pad signal port multiplex selection for pad pad_io_b_10. The programmed value defines which port
              is connected to the pad.
          '''
          swaccess: "rw"
          hwaccess: "hro"
          resval: 0
          fields: [
              {
                  bits: "4:0"
                  enum: [
                      { value: "0", name: "register", desc: "Connects the Pad to the internal configuration register."}
                      { value: "1", name: "port_spi2_spi_cs", desc: "Connect port spi_cs from port group spi2 to this pad." }
                      { value: "2", name: "port_spi2_spi_miso", desc: "Connect port spi_miso from port group spi2 to this pad." }
                      { value: "3", name: "port_spi2_spi_mosi", desc: "Connect port spi_mosi from port group spi2 to this pad." }
                      { value: "4", name: "port_spi2_spi_sck", desc: "Connect port spi_sck from port group spi2 to this pad." }
                      { value: "5", name: "port_spi3_spi_cs", desc: "Connect port spi_cs from port group spi3 to this pad." }
                      { value: "6", name: "port_spi3_spi_miso", desc: "Connect port spi_miso from port group spi3 to this pad." }
                      { value: "7", name: "port_spi3_spi_mosi", desc: "Connect port spi_mosi from port group spi3 to this pad." }
                      { value: "8", name: "port_spi3_spi_sck", desc: "Connect port spi_sck from port group spi3 to this pad." }
                      { value: "9", name: "port_spi4_spi_cs", desc: "Connect port spi_cs from port group spi4 to this pad." }
                      { value: "10", name: "port_spi4_spi_miso", desc: "Connect port spi_miso from port group spi4 to this pad." }
                      { value: "11", name: "port_spi4_spi_mosi", desc: "Connect port spi_mosi from port group spi4 to this pad." }
                      { value: "12", name: "port_spi4_spi_sck", desc: "Connect port spi_sck from port group spi4 to this pad." }
                      { value: "13", name: "port_spi5_spi_cs", desc: "Connect port spi_cs from port group spi5 to this pad." }
                      { value: "14", name: "port_spi5_spi_miso", desc: "Connect port spi_miso from port group spi5 to this pad." }
                      { value: "15", name: "port_spi5_spi_mosi", desc: "Connect port spi_mosi from port group spi5 to this pad." }
                      { value: "16", name: "port_spi5_spi_sck", desc: "Connect port spi_sck from port group spi5 to this pad." }
                      { value: "17", name: "port_spi6_spi_cs", desc: "Connect port spi_cs from port group spi6 to this pad." }
                      { value: "18", name: "port_spi6_spi_miso", desc: "Connect port spi_miso from port group spi6 to this pad." }
                      { value: "19", name: "port_spi6_spi_mosi", desc: "Connect port spi_mosi from port group spi6 to this pad." }
                      { value: "20", name: "port_spi6_spi_sck", desc: "Connect port spi_sck from port group spi6 to this pad." }
                  ]
              }
          ]
      }

      {
          name: PAD_IO_B_11_CFG
          desc: '''
            Pad signal configuration.
          '''
          swaccess: "rw"
          fields: [
            {
                bits: "0"
                name: chip2pad
                desc: '''
                     The signal that connects to the pads TX driver
                '''
                swaccess: "rw"
                hwaccess: "hro"
                resval: "0"
            },
            {
                bits: "1"
                name: oen
                desc: '''
                     Output enable signal, active low
                '''
                swaccess: "rw"
                hwaccess: "hro"
                resval: "1"
            },
          ]
      }

       {
          name: PAD_IO_B_11_MUX_SEL
          desc: '''
              Pad signal port multiplex selection for pad pad_io_b_11. The programmed value defines which port
              is connected to the pad.
          '''
          swaccess: "rw"
          hwaccess: "hro"
          resval: 0
          fields: [
              {
                  bits: "4:0"
                  enum: [
                      { value: "0", name: "register", desc: "Connects the Pad to the internal configuration register."}
                      { value: "1", name: "port_spi2_spi_cs", desc: "Connect port spi_cs from port group spi2 to this pad." }
                      { value: "2", name: "port_spi2_spi_miso", desc: "Connect port spi_miso from port group spi2 to this pad." }
                      { value: "3", name: "port_spi2_spi_mosi", desc: "Connect port spi_mosi from port group spi2 to this pad." }
                      { value: "4", name: "port_spi2_spi_sck", desc: "Connect port spi_sck from port group spi2 to this pad." }
                      { value: "5", name: "port_spi3_spi_cs", desc: "Connect port spi_cs from port group spi3 to this pad." }
                      { value: "6", name: "port_spi3_spi_miso", desc: "Connect port spi_miso from port group spi3 to this pad." }
                      { value: "7", name: "port_spi3_spi_mosi", desc: "Connect port spi_mosi from port group spi3 to this pad." }
                      { value: "8", name: "port_spi3_spi_sck", desc: "Connect port spi_sck from port group spi3 to this pad." }
                      { value: "9", name: "port_spi4_spi_cs", desc: "Connect port spi_cs from port group spi4 to this pad." }
                      { value: "10", name: "port_spi4_spi_miso", desc: "Connect port spi_miso from port group spi4 to this pad." }
                      { value: "11", name: "port_spi4_spi_mosi", desc: "Connect port spi_mosi from port group spi4 to this pad." }
                      { value: "12", name: "port_spi4_spi_sck", desc: "Connect port spi_sck from port group spi4 to this pad." }
                      { value: "13", name: "port_spi5_spi_cs", desc: "Connect port spi_cs from port group spi5 to this pad." }
                      { value: "14", name: "port_spi5_spi_miso", desc: "Connect port spi_miso from port group spi5 to this pad." }
                      { value: "15", name: "port_spi5_spi_mosi", desc: "Connect port spi_mosi from port group spi5 to this pad." }
                      { value: "16", name: "port_spi5_spi_sck", desc: "Connect port spi_sck from port group spi5 to this pad." }
                      { value: "17", name: "port_spi6_spi_cs", desc: "Connect port spi_cs from port group spi6 to this pad." }
                      { value: "18", name: "port_spi6_spi_miso", desc: "Connect port spi_miso from port group spi6 to this pad." }
                      { value: "19", name: "port_spi6_spi_mosi", desc: "Connect port spi_mosi from port group spi6 to this pad." }
                      { value: "20", name: "port_spi6_spi_sck", desc: "Connect port spi_sck from port group spi6 to this pad." }
                  ]
              }
          ]
      }

      {
          name: PAD_IO_B_12_CFG
          desc: '''
            Pad signal configuration.
          '''
          swaccess: "rw"
          fields: [
            {
                bits: "0"
                name: chip2pad
                desc: '''
                     The signal that connects to the pads TX driver
                '''
                swaccess: "rw"
                hwaccess: "hro"
                resval: "0"
            },
            {
                bits: "1"
                name: oen
                desc: '''
                     Output enable signal, active low
                '''
                swaccess: "rw"
                hwaccess: "hro"
                resval: "1"
            },
          ]
      }

       {
          name: PAD_IO_B_12_MUX_SEL
          desc: '''
              Pad signal port multiplex selection for pad pad_io_b_12. The programmed value defines which port
              is connected to the pad.
          '''
          swaccess: "rw"
          hwaccess: "hro"
          resval: 0
          fields: [
              {
                  bits: "4:0"
                  enum: [
                      { value: "0", name: "register", desc: "Connects the Pad to the internal configuration register."}
                      { value: "1", name: "port_spi2_spi_cs", desc: "Connect port spi_cs from port group spi2 to this pad." }
                      { value: "2", name: "port_spi2_spi_miso", desc: "Connect port spi_miso from port group spi2 to this pad." }
                      { value: "3", name: "port_spi2_spi_mosi", desc: "Connect port spi_mosi from port group spi2 to this pad." }
                      { value: "4", name: "port_spi2_spi_sck", desc: "Connect port spi_sck from port group spi2 to this pad." }
                      { value: "5", name: "port_spi3_spi_cs", desc: "Connect port spi_cs from port group spi3 to this pad." }
                      { value: "6", name: "port_spi3_spi_miso", desc: "Connect port spi_miso from port group spi3 to this pad." }
                      { value: "7", name: "port_spi3_spi_mosi", desc: "Connect port spi_mosi from port group spi3 to this pad." }
                      { value: "8", name: "port_spi3_spi_sck", desc: "Connect port spi_sck from port group spi3 to this pad." }
                      { value: "9", name: "port_spi4_spi_cs", desc: "Connect port spi_cs from port group spi4 to this pad." }
                      { value: "10", name: "port_spi4_spi_miso", desc: "Connect port spi_miso from port group spi4 to this pad." }
                      { value: "11", name: "port_spi4_spi_mosi", desc: "Connect port spi_mosi from port group spi4 to this pad." }
                      { value: "12", name: "port_spi4_spi_sck", desc: "Connect port spi_sck from port group spi4 to this pad." }
                      { value: "13", name: "port_spi5_spi_cs", desc: "Connect port spi_cs from port group spi5 to this pad." }
                      { value: "14", name: "port_spi5_spi_miso", desc: "Connect port spi_miso from port group spi5 to this pad." }
                      { value: "15", name: "port_spi5_spi_mosi", desc: "Connect port spi_mosi from port group spi5 to this pad." }
                      { value: "16", name: "port_spi5_spi_sck", desc: "Connect port spi_sck from port group spi5 to this pad." }
                      { value: "17", name: "port_spi6_spi_cs", desc: "Connect port spi_cs from port group spi6 to this pad." }
                      { value: "18", name: "port_spi6_spi_miso", desc: "Connect port spi_miso from port group spi6 to this pad." }
                      { value: "19", name: "port_spi6_spi_mosi", desc: "Connect port spi_mosi from port group spi6 to this pad." }
                      { value: "20", name: "port_spi6_spi_sck", desc: "Connect port spi_sck from port group spi6 to this pad." }
                  ]
              }
          ]
      }

      {
          name: PAD_IO_B_13_CFG
          desc: '''
            Pad signal configuration.
          '''
          swaccess: "rw"
          fields: [
            {
                bits: "0"
                name: chip2pad
                desc: '''
                     The signal that connects to the pads TX driver
                '''
                swaccess: "rw"
                hwaccess: "hro"
                resval: "0"
            },
            {
                bits: "1"
                name: oen
                desc: '''
                     Output enable signal, active low
                '''
                swaccess: "rw"
                hwaccess: "hro"
                resval: "1"
            },
          ]
      }

       {
          name: PAD_IO_B_13_MUX_SEL
          desc: '''
              Pad signal port multiplex selection for pad pad_io_b_13. The programmed value defines which port
              is connected to the pad.
          '''
          swaccess: "rw"
          hwaccess: "hro"
          resval: 0
          fields: [
              {
                  bits: "4:0"
                  enum: [
                      { value: "0", name: "register", desc: "Connects the Pad to the internal configuration register."}
                      { value: "1", name: "port_spi2_spi_cs", desc: "Connect port spi_cs from port group spi2 to this pad." }
                      { value: "2", name: "port_spi2_spi_miso", desc: "Connect port spi_miso from port group spi2 to this pad." }
                      { value: "3", name: "port_spi2_spi_mosi", desc: "Connect port spi_mosi from port group spi2 to this pad." }
                      { value: "4", name: "port_spi2_spi_sck", desc: "Connect port spi_sck from port group spi2 to this pad." }
                      { value: "5", name: "port_spi3_spi_cs", desc: "Connect port spi_cs from port group spi3 to this pad." }
                      { value: "6", name: "port_spi3_spi_miso", desc: "Connect port spi_miso from port group spi3 to this pad." }
                      { value: "7", name: "port_spi3_spi_mosi", desc: "Connect port spi_mosi from port group spi3 to this pad." }
                      { value: "8", name: "port_spi3_spi_sck", desc: "Connect port spi_sck from port group spi3 to this pad." }
                      { value: "9", name: "port_spi4_spi_cs", desc: "Connect port spi_cs from port group spi4 to this pad." }
                      { value: "10", name: "port_spi4_spi_miso", desc: "Connect port spi_miso from port group spi4 to this pad." }
                      { value: "11", name: "port_spi4_spi_mosi", desc: "Connect port spi_mosi from port group spi4 to this pad." }
                      { value: "12", name: "port_spi4_spi_sck", desc: "Connect port spi_sck from port group spi4 to this pad." }
                      { value: "13", name: "port_spi5_spi_cs", desc: "Connect port spi_cs from port group spi5 to this pad." }
                      { value: "14", name: "port_spi5_spi_miso", desc: "Connect port spi_miso from port group spi5 to this pad." }
                      { value: "15", name: "port_spi5_spi_mosi", desc: "Connect port spi_mosi from port group spi5 to this pad." }
                      { value: "16", name: "port_spi5_spi_sck", desc: "Connect port spi_sck from port group spi5 to this pad." }
                      { value: "17", name: "port_spi6_spi_cs", desc: "Connect port spi_cs from port group spi6 to this pad." }
                      { value: "18", name: "port_spi6_spi_miso", desc: "Connect port spi_miso from port group spi6 to this pad." }
                      { value: "19", name: "port_spi6_spi_mosi", desc: "Connect port spi_mosi from port group spi6 to this pad." }
                      { value: "20", name: "port_spi6_spi_sck", desc: "Connect port spi_sck from port group spi6 to this pad." }
                  ]
              }
          ]
      }

      {
          name: PAD_IO_B_14_CFG
          desc: '''
            Pad signal configuration.
          '''
          swaccess: "rw"
          fields: [
            {
                bits: "0"
                name: chip2pad
                desc: '''
                     The signal that connects to the pads TX driver
                '''
                swaccess: "rw"
                hwaccess: "hro"
                resval: "0"
            },
            {
                bits: "1"
                name: oen
                desc: '''
                     Output enable signal, active low
                '''
                swaccess: "rw"
                hwaccess: "hro"
                resval: "1"
            },
          ]
      }

       {
          name: PAD_IO_B_14_MUX_SEL
          desc: '''
              Pad signal port multiplex selection for pad pad_io_b_14. The programmed value defines which port
              is connected to the pad.
          '''
          swaccess: "rw"
          hwaccess: "hro"
          resval: 0
          fields: [
              {
                  bits: "4:0"
                  enum: [
                      { value: "0", name: "register", desc: "Connects the Pad to the internal configuration register."}
                      { value: "1", name: "port_spi2_spi_cs", desc: "Connect port spi_cs from port group spi2 to this pad." }
                      { value: "2", name: "port_spi2_spi_miso", desc: "Connect port spi_miso from port group spi2 to this pad." }
                      { value: "3", name: "port_spi2_spi_mosi", desc: "Connect port spi_mosi from port group spi2 to this pad." }
                      { value: "4", name: "port_spi2_spi_sck", desc: "Connect port spi_sck from port group spi2 to this pad." }
                      { value: "5", name: "port_spi3_spi_cs", desc: "Connect port spi_cs from port group spi3 to this pad." }
                      { value: "6", name: "port_spi3_spi_miso", desc: "Connect port spi_miso from port group spi3 to this pad." }
                      { value: "7", name: "port_spi3_spi_mosi", desc: "Connect port spi_mosi from port group spi3 to this pad." }
                      { value: "8", name: "port_spi3_spi_sck", desc: "Connect port spi_sck from port group spi3 to this pad." }
                      { value: "9", name: "port_spi4_spi_cs", desc: "Connect port spi_cs from port group spi4 to this pad." }
                      { value: "10", name: "port_spi4_spi_miso", desc: "Connect port spi_miso from port group spi4 to this pad." }
                      { value: "11", name: "port_spi4_spi_mosi", desc: "Connect port spi_mosi from port group spi4 to this pad." }
                      { value: "12", name: "port_spi4_spi_sck", desc: "Connect port spi_sck from port group spi4 to this pad." }
                      { value: "13", name: "port_spi5_spi_cs", desc: "Connect port spi_cs from port group spi5 to this pad." }
                      { value: "14", name: "port_spi5_spi_miso", desc: "Connect port spi_miso from port group spi5 to this pad." }
                      { value: "15", name: "port_spi5_spi_mosi", desc: "Connect port spi_mosi from port group spi5 to this pad." }
                      { value: "16", name: "port_spi5_spi_sck", desc: "Connect port spi_sck from port group spi5 to this pad." }
                      { value: "17", name: "port_spi6_spi_cs", desc: "Connect port spi_cs from port group spi6 to this pad." }
                      { value: "18", name: "port_spi6_spi_miso", desc: "Connect port spi_miso from port group spi6 to this pad." }
                      { value: "19", name: "port_spi6_spi_mosi", desc: "Connect port spi_mosi from port group spi6 to this pad." }
                      { value: "20", name: "port_spi6_spi_sck", desc: "Connect port spi_sck from port group spi6 to this pad." }
                  ]
              }
          ]
      }

      {
          name: PAD_IO_B_15_CFG
          desc: '''
            Pad signal configuration.
          '''
          swaccess: "rw"
          fields: [
            {
                bits: "0"
                name: chip2pad
                desc: '''
                     The signal that connects to the pads TX driver
                '''
                swaccess: "rw"
                hwaccess: "hro"
                resval: "0"
            },
            {
                bits: "1"
                name: oen
                desc: '''
                     Output enable signal, active low
                '''
                swaccess: "rw"
                hwaccess: "hro"
                resval: "1"
            },
          ]
      }

       {
          name: PAD_IO_B_15_MUX_SEL
          desc: '''
              Pad signal port multiplex selection for pad pad_io_b_15. The programmed value defines which port
              is connected to the pad.
          '''
          swaccess: "rw"
          hwaccess: "hro"
          resval: 0
          fields: [
              {
                  bits: "4:0"
                  enum: [
                      { value: "0", name: "register", desc: "Connects the Pad to the internal configuration register."}
                      { value: "1", name: "port_spi2_spi_cs", desc: "Connect port spi_cs from port group spi2 to this pad." }
                      { value: "2", name: "port_spi2_spi_miso", desc: "Connect port spi_miso from port group spi2 to this pad." }
                      { value: "3", name: "port_spi2_spi_mosi", desc: "Connect port spi_mosi from port group spi2 to this pad." }
                      { value: "4", name: "port_spi2_spi_sck", desc: "Connect port spi_sck from port group spi2 to this pad." }
                      { value: "5", name: "port_spi3_spi_cs", desc: "Connect port spi_cs from port group spi3 to this pad." }
                      { value: "6", name: "port_spi3_spi_miso", desc: "Connect port spi_miso from port group spi3 to this pad." }
                      { value: "7", name: "port_spi3_spi_mosi", desc: "Connect port spi_mosi from port group spi3 to this pad." }
                      { value: "8", name: "port_spi3_spi_sck", desc: "Connect port spi_sck from port group spi3 to this pad." }
                      { value: "9", name: "port_spi4_spi_cs", desc: "Connect port spi_cs from port group spi4 to this pad." }
                      { value: "10", name: "port_spi4_spi_miso", desc: "Connect port spi_miso from port group spi4 to this pad." }
                      { value: "11", name: "port_spi4_spi_mosi", desc: "Connect port spi_mosi from port group spi4 to this pad." }
                      { value: "12", name: "port_spi4_spi_sck", desc: "Connect port spi_sck from port group spi4 to this pad." }
                      { value: "13", name: "port_spi5_spi_cs", desc: "Connect port spi_cs from port group spi5 to this pad." }
                      { value: "14", name: "port_spi5_spi_miso", desc: "Connect port spi_miso from port group spi5 to this pad." }
                      { value: "15", name: "port_spi5_spi_mosi", desc: "Connect port spi_mosi from port group spi5 to this pad." }
                      { value: "16", name: "port_spi5_spi_sck", desc: "Connect port spi_sck from port group spi5 to this pad." }
                      { value: "17", name: "port_spi6_spi_cs", desc: "Connect port spi_cs from port group spi6 to this pad." }
                      { value: "18", name: "port_spi6_spi_miso", desc: "Connect port spi_miso from port group spi6 to this pad." }
                      { value: "19", name: "port_spi6_spi_mosi", desc: "Connect port spi_mosi from port group spi6 to this pad." }
                      { value: "20", name: "port_spi6_spi_sck", desc: "Connect port spi_sck from port group spi6 to this pad." }
                  ]
              }
          ]
      }

      {
          name: PAD_IO_B_16_CFG
          desc: '''
            Pad signal configuration.
          '''
          swaccess: "rw"
          fields: [
            {
                bits: "0"
                name: chip2pad
                desc: '''
                     The signal that connects to the pads TX driver
                '''
                swaccess: "rw"
                hwaccess: "hro"
                resval: "0"
            },
            {
                bits: "1"
                name: oen
                desc: '''
                     Output enable signal, active low
                '''
                swaccess: "rw"
                hwaccess: "hro"
                resval: "1"
            },
          ]
      }

       {
          name: PAD_IO_B_16_MUX_SEL
          desc: '''
              Pad signal port multiplex selection for pad pad_io_b_16. The programmed value defines which port
              is connected to the pad.
          '''
          swaccess: "rw"
          hwaccess: "hro"
          resval: 0
          fields: [
              {
                  bits: "4:0"
                  enum: [
                      { value: "0", name: "register", desc: "Connects the Pad to the internal configuration register."}
                      { value: "1", name: "port_spi2_spi_cs", desc: "Connect port spi_cs from port group spi2 to this pad." }
                      { value: "2", name: "port_spi2_spi_miso", desc: "Connect port spi_miso from port group spi2 to this pad." }
                      { value: "3", name: "port_spi2_spi_mosi", desc: "Connect port spi_mosi from port group spi2 to this pad." }
                      { value: "4", name: "port_spi2_spi_sck", desc: "Connect port spi_sck from port group spi2 to this pad." }
                      { value: "5", name: "port_spi3_spi_cs", desc: "Connect port spi_cs from port group spi3 to this pad." }
                      { value: "6", name: "port_spi3_spi_miso", desc: "Connect port spi_miso from port group spi3 to this pad." }
                      { value: "7", name: "port_spi3_spi_mosi", desc: "Connect port spi_mosi from port group spi3 to this pad." }
                      { value: "8", name: "port_spi3_spi_sck", desc: "Connect port spi_sck from port group spi3 to this pad." }
                      { value: "9", name: "port_spi4_spi_cs", desc: "Connect port spi_cs from port group spi4 to this pad." }
                      { value: "10", name: "port_spi4_spi_miso", desc: "Connect port spi_miso from port group spi4 to this pad." }
                      { value: "11", name: "port_spi4_spi_mosi", desc: "Connect port spi_mosi from port group spi4 to this pad." }
                      { value: "12", name: "port_spi4_spi_sck", desc: "Connect port spi_sck from port group spi4 to this pad." }
                      { value: "13", name: "port_spi5_spi_cs", desc: "Connect port spi_cs from port group spi5 to this pad." }
                      { value: "14", name: "port_spi5_spi_miso", desc: "Connect port spi_miso from port group spi5 to this pad." }
                      { value: "15", name: "port_spi5_spi_mosi", desc: "Connect port spi_mosi from port group spi5 to this pad." }
                      { value: "16", name: "port_spi5_spi_sck", desc: "Connect port spi_sck from port group spi5 to this pad." }
                      { value: "17", name: "port_spi6_spi_cs", desc: "Connect port spi_cs from port group spi6 to this pad." }
                      { value: "18", name: "port_spi6_spi_miso", desc: "Connect port spi_miso from port group spi6 to this pad." }
                      { value: "19", name: "port_spi6_spi_mosi", desc: "Connect port spi_mosi from port group spi6 to this pad." }
                      { value: "20", name: "port_spi6_spi_sck", desc: "Connect port spi_sck from port group spi6 to this pad." }
                  ]
              }
          ]
      }

      {
          name: PAD_IO_B_17_CFG
          desc: '''
            Pad signal configuration.
          '''
          swaccess: "rw"
          fields: [
            {
                bits: "0"
                name: chip2pad
                desc: '''
                     The signal that connects to the pads TX driver
                '''
                swaccess: "rw"
                hwaccess: "hro"
                resval: "0"
            },
            {
                bits: "1"
                name: oen
                desc: '''
                     Output enable signal, active low
                '''
                swaccess: "rw"
                hwaccess: "hro"
                resval: "1"
            },
          ]
      }

       {
          name: PAD_IO_B_17_MUX_SEL
          desc: '''
              Pad signal port multiplex selection for pad pad_io_b_17. The programmed value defines which port
              is connected to the pad.
          '''
          swaccess: "rw"
          hwaccess: "hro"
          resval: 0
          fields: [
              {
                  bits: "4:0"
                  enum: [
                      { value: "0", name: "register", desc: "Connects the Pad to the internal configuration register."}
                      { value: "1", name: "port_spi2_spi_cs", desc: "Connect port spi_cs from port group spi2 to this pad." }
                      { value: "2", name: "port_spi2_spi_miso", desc: "Connect port spi_miso from port group spi2 to this pad." }
                      { value: "3", name: "port_spi2_spi_mosi", desc: "Connect port spi_mosi from port group spi2 to this pad." }
                      { value: "4", name: "port_spi2_spi_sck", desc: "Connect port spi_sck from port group spi2 to this pad." }
                      { value: "5", name: "port_spi3_spi_cs", desc: "Connect port spi_cs from port group spi3 to this pad." }
                      { value: "6", name: "port_spi3_spi_miso", desc: "Connect port spi_miso from port group spi3 to this pad." }
                      { value: "7", name: "port_spi3_spi_mosi", desc: "Connect port spi_mosi from port group spi3 to this pad." }
                      { value: "8", name: "port_spi3_spi_sck", desc: "Connect port spi_sck from port group spi3 to this pad." }
                      { value: "9", name: "port_spi4_spi_cs", desc: "Connect port spi_cs from port group spi4 to this pad." }
                      { value: "10", name: "port_spi4_spi_miso", desc: "Connect port spi_miso from port group spi4 to this pad." }
                      { value: "11", name: "port_spi4_spi_mosi", desc: "Connect port spi_mosi from port group spi4 to this pad." }
                      { value: "12", name: "port_spi4_spi_sck", desc: "Connect port spi_sck from port group spi4 to this pad." }
                      { value: "13", name: "port_spi5_spi_cs", desc: "Connect port spi_cs from port group spi5 to this pad." }
                      { value: "14", name: "port_spi5_spi_miso", desc: "Connect port spi_miso from port group spi5 to this pad." }
                      { value: "15", name: "port_spi5_spi_mosi", desc: "Connect port spi_mosi from port group spi5 to this pad." }
                      { value: "16", name: "port_spi5_spi_sck", desc: "Connect port spi_sck from port group spi5 to this pad." }
                      { value: "17", name: "port_spi6_spi_cs", desc: "Connect port spi_cs from port group spi6 to this pad." }
                      { value: "18", name: "port_spi6_spi_miso", desc: "Connect port spi_miso from port group spi6 to this pad." }
                      { value: "19", name: "port_spi6_spi_mosi", desc: "Connect port spi_mosi from port group spi6 to this pad." }
                      { value: "20", name: "port_spi6_spi_sck", desc: "Connect port spi_sck from port group spi6 to this pad." }
                  ]
              }
          ]
      }

      {
          name: PAD_IO_B_18_CFG
          desc: '''
            Pad signal configuration.
          '''
          swaccess: "rw"
          fields: [
            {
                bits: "0"
                name: chip2pad
                desc: '''
                     The signal that connects to the pads TX driver
                '''
                swaccess: "rw"
                hwaccess: "hro"
                resval: "0"
            },
            {
                bits: "1"
                name: oen
                desc: '''
                     Output enable signal, active low
                '''
                swaccess: "rw"
                hwaccess: "hro"
                resval: "1"
            },
          ]
      }

       {
          name: PAD_IO_B_18_MUX_SEL
          desc: '''
              Pad signal port multiplex selection for pad pad_io_b_18. The programmed value defines which port
              is connected to the pad.
          '''
          swaccess: "rw"
          hwaccess: "hro"
          resval: 0
          fields: [
              {
                  bits: "4:0"
                  enum: [
                      { value: "0", name: "register", desc: "Connects the Pad to the internal configuration register."}
                      { value: "1", name: "port_spi2_spi_cs", desc: "Connect port spi_cs from port group spi2 to this pad." }
                      { value: "2", name: "port_spi2_spi_miso", desc: "Connect port spi_miso from port group spi2 to this pad." }
                      { value: "3", name: "port_spi2_spi_mosi", desc: "Connect port spi_mosi from port group spi2 to this pad." }
                      { value: "4", name: "port_spi2_spi_sck", desc: "Connect port spi_sck from port group spi2 to this pad." }
                      { value: "5", name: "port_spi3_spi_cs", desc: "Connect port spi_cs from port group spi3 to this pad." }
                      { value: "6", name: "port_spi3_spi_miso", desc: "Connect port spi_miso from port group spi3 to this pad." }
                      { value: "7", name: "port_spi3_spi_mosi", desc: "Connect port spi_mosi from port group spi3 to this pad." }
                      { value: "8", name: "port_spi3_spi_sck", desc: "Connect port spi_sck from port group spi3 to this pad." }
                      { value: "9", name: "port_spi4_spi_cs", desc: "Connect port spi_cs from port group spi4 to this pad." }
                      { value: "10", name: "port_spi4_spi_miso", desc: "Connect port spi_miso from port group spi4 to this pad." }
                      { value: "11", name: "port_spi4_spi_mosi", desc: "Connect port spi_mosi from port group spi4 to this pad." }
                      { value: "12", name: "port_spi4_spi_sck", desc: "Connect port spi_sck from port group spi4 to this pad." }
                      { value: "13", name: "port_spi5_spi_cs", desc: "Connect port spi_cs from port group spi5 to this pad." }
                      { value: "14", name: "port_spi5_spi_miso", desc: "Connect port spi_miso from port group spi5 to this pad." }
                      { value: "15", name: "port_spi5_spi_mosi", desc: "Connect port spi_mosi from port group spi5 to this pad." }
                      { value: "16", name: "port_spi5_spi_sck", desc: "Connect port spi_sck from port group spi5 to this pad." }
                      { value: "17", name: "port_spi6_spi_cs", desc: "Connect port spi_cs from port group spi6 to this pad." }
                      { value: "18", name: "port_spi6_spi_miso", desc: "Connect port spi_miso from port group spi6 to this pad." }
                      { value: "19", name: "port_spi6_spi_mosi", desc: "Connect port spi_mosi from port group spi6 to this pad." }
                      { value: "20", name: "port_spi6_spi_sck", desc: "Connect port spi_sck from port group spi6 to this pad." }
                  ]
              }
          ]
      }

      {
          name: PAD_IO_B_19_CFG
          desc: '''
            Pad signal configuration.
          '''
          swaccess: "rw"
          fields: [
            {
                bits: "0"
                name: chip2pad
                desc: '''
                     The signal that connects to the pads TX driver
                '''
                swaccess: "rw"
                hwaccess: "hro"
                resval: "0"
            },
            {
                bits: "1"
                name: oen
                desc: '''
                     Output enable signal, active low
                '''
                swaccess: "rw"
                hwaccess: "hro"
                resval: "1"
            },
          ]
      }

       {
          name: PAD_IO_B_19_MUX_SEL
          desc: '''
              Pad signal port multiplex selection for pad pad_io_b_19. The programmed value defines which port
              is connected to the pad.
          '''
          swaccess: "rw"
          hwaccess: "hro"
          resval: 0
          fields: [
              {
                  bits: "4:0"
                  enum: [
                      { value: "0", name: "register", desc: "Connects the Pad to the internal configuration register."}
                      { value: "1", name: "port_spi2_spi_cs", desc: "Connect port spi_cs from port group spi2 to this pad." }
                      { value: "2", name: "port_spi2_spi_miso", desc: "Connect port spi_miso from port group spi2 to this pad." }
                      { value: "3", name: "port_spi2_spi_mosi", desc: "Connect port spi_mosi from port group spi2 to this pad." }
                      { value: "4", name: "port_spi2_spi_sck", desc: "Connect port spi_sck from port group spi2 to this pad." }
                      { value: "5", name: "port_spi3_spi_cs", desc: "Connect port spi_cs from port group spi3 to this pad." }
                      { value: "6", name: "port_spi3_spi_miso", desc: "Connect port spi_miso from port group spi3 to this pad." }
                      { value: "7", name: "port_spi3_spi_mosi", desc: "Connect port spi_mosi from port group spi3 to this pad." }
                      { value: "8", name: "port_spi3_spi_sck", desc: "Connect port spi_sck from port group spi3 to this pad." }
                      { value: "9", name: "port_spi4_spi_cs", desc: "Connect port spi_cs from port group spi4 to this pad." }
                      { value: "10", name: "port_spi4_spi_miso", desc: "Connect port spi_miso from port group spi4 to this pad." }
                      { value: "11", name: "port_spi4_spi_mosi", desc: "Connect port spi_mosi from port group spi4 to this pad." }
                      { value: "12", name: "port_spi4_spi_sck", desc: "Connect port spi_sck from port group spi4 to this pad." }
                      { value: "13", name: "port_spi5_spi_cs", desc: "Connect port spi_cs from port group spi5 to this pad." }
                      { value: "14", name: "port_spi5_spi_miso", desc: "Connect port spi_miso from port group spi5 to this pad." }
                      { value: "15", name: "port_spi5_spi_mosi", desc: "Connect port spi_mosi from port group spi5 to this pad." }
                      { value: "16", name: "port_spi5_spi_sck", desc: "Connect port spi_sck from port group spi5 to this pad." }
                      { value: "17", name: "port_spi6_spi_cs", desc: "Connect port spi_cs from port group spi6 to this pad." }
                      { value: "18", name: "port_spi6_spi_miso", desc: "Connect port spi_miso from port group spi6 to this pad." }
                      { value: "19", name: "port_spi6_spi_mosi", desc: "Connect port spi_mosi from port group spi6 to this pad." }
                      { value: "20", name: "port_spi6_spi_sck", desc: "Connect port spi_sck from port group spi6 to this pad." }
                  ]
              }
          ]
      }

      {
          name: PAD_IO_C_00_CFG
          desc: '''
            Pad signal configuration.
          '''
          swaccess: "rw"
          fields: [
            {
                bits: "0"
                name: chip2pad
                desc: '''
                     The signal that connects to the pads TX driver
                '''
                swaccess: "rw"
                hwaccess: "hro"
                resval: "0"
            },
            {
                bits: "1"
                name: oen
                desc: '''
                     Output enable signal, active low
                '''
                swaccess: "rw"
                hwaccess: "hro"
                resval: "1"
            },
          ]
      }

       {
          name: PAD_IO_C_00_MUX_SEL
          desc: '''
              Pad signal port multiplex selection for pad pad_io_c_00. The programmed value defines which port
              is connected to the pad.
          '''
          swaccess: "rw"
          hwaccess: "hro"
          resval: 0
          fields: [
              {
                  bits: "3:0"
                  enum: [
                      { value: "0", name: "register", desc: "Connects the Pad to the internal configuration register."}
                      { value: "1", name: "port_qspi_qspi_csn", desc: "Connect port qspi_csn from port group qspi to this pad." }
                      { value: "2", name: "port_qspi_qspi_sck", desc: "Connect port qspi_sck from port group qspi to this pad." }
                      { value: "3", name: "port_qspi_qspi_sd0", desc: "Connect port qspi_sd0 from port group qspi to this pad." }
                      { value: "4", name: "port_qspi_qspi_sd1", desc: "Connect port qspi_sd1 from port group qspi to this pad." }
                      { value: "5", name: "port_qspi_qspi_sd2", desc: "Connect port qspi_sd2 from port group qspi to this pad." }
                      { value: "6", name: "port_qspi_qspi_sd3", desc: "Connect port qspi_sd3 from port group qspi to this pad." }
                      { value: "7", name: "port_sdio0_sdio_clk", desc: "Connect port sdio_clk from port group sdio0 to this pad." }
                      { value: "8", name: "port_sdio0_sdio_cmd", desc: "Connect port sdio_cmd from port group sdio0 to this pad." }
                      { value: "9", name: "port_sdio0_sdio_data0", desc: "Connect port sdio_data0 from port group sdio0 to this pad." }
                      { value: "10", name: "port_sdio0_sdio_data1", desc: "Connect port sdio_data1 from port group sdio0 to this pad." }
                      { value: "11", name: "port_sdio0_sdio_data2", desc: "Connect port sdio_data2 from port group sdio0 to this pad." }
                      { value: "12", name: "port_sdio0_sdio_data3", desc: "Connect port sdio_data3 from port group sdio0 to this pad." }
                  ]
              }
          ]
      }

      {
          name: PAD_IO_C_01_CFG
          desc: '''
            Pad signal configuration.
          '''
          swaccess: "rw"
          fields: [
            {
                bits: "0"
                name: chip2pad
                desc: '''
                     The signal that connects to the pads TX driver
                '''
                swaccess: "rw"
                hwaccess: "hro"
                resval: "0"
            },
            {
                bits: "1"
                name: oen
                desc: '''
                     Output enable signal, active low
                '''
                swaccess: "rw"
                hwaccess: "hro"
                resval: "1"
            },
          ]
      }

       {
          name: PAD_IO_C_01_MUX_SEL
          desc: '''
              Pad signal port multiplex selection for pad pad_io_c_01. The programmed value defines which port
              is connected to the pad.
          '''
          swaccess: "rw"
          hwaccess: "hro"
          resval: 0
          fields: [
              {
                  bits: "3:0"
                  enum: [
                      { value: "0", name: "register", desc: "Connects the Pad to the internal configuration register."}
                      { value: "1", name: "port_qspi_qspi_csn", desc: "Connect port qspi_csn from port group qspi to this pad." }
                      { value: "2", name: "port_qspi_qspi_sck", desc: "Connect port qspi_sck from port group qspi to this pad." }
                      { value: "3", name: "port_qspi_qspi_sd0", desc: "Connect port qspi_sd0 from port group qspi to this pad." }
                      { value: "4", name: "port_qspi_qspi_sd1", desc: "Connect port qspi_sd1 from port group qspi to this pad." }
                      { value: "5", name: "port_qspi_qspi_sd2", desc: "Connect port qspi_sd2 from port group qspi to this pad." }
                      { value: "6", name: "port_qspi_qspi_sd3", desc: "Connect port qspi_sd3 from port group qspi to this pad." }
                      { value: "7", name: "port_sdio0_sdio_clk", desc: "Connect port sdio_clk from port group sdio0 to this pad." }
                      { value: "8", name: "port_sdio0_sdio_cmd", desc: "Connect port sdio_cmd from port group sdio0 to this pad." }
                      { value: "9", name: "port_sdio0_sdio_data0", desc: "Connect port sdio_data0 from port group sdio0 to this pad." }
                      { value: "10", name: "port_sdio0_sdio_data1", desc: "Connect port sdio_data1 from port group sdio0 to this pad." }
                      { value: "11", name: "port_sdio0_sdio_data2", desc: "Connect port sdio_data2 from port group sdio0 to this pad." }
                      { value: "12", name: "port_sdio0_sdio_data3", desc: "Connect port sdio_data3 from port group sdio0 to this pad." }
                  ]
              }
          ]
      }

      {
          name: PAD_IO_C_02_CFG
          desc: '''
            Pad signal configuration.
          '''
          swaccess: "rw"
          fields: [
            {
                bits: "0"
                name: chip2pad
                desc: '''
                     The signal that connects to the pads TX driver
                '''
                swaccess: "rw"
                hwaccess: "hro"
                resval: "0"
            },
            {
                bits: "1"
                name: oen
                desc: '''
                     Output enable signal, active low
                '''
                swaccess: "rw"
                hwaccess: "hro"
                resval: "1"
            },
          ]
      }

       {
          name: PAD_IO_C_02_MUX_SEL
          desc: '''
              Pad signal port multiplex selection for pad pad_io_c_02. The programmed value defines which port
              is connected to the pad.
          '''
          swaccess: "rw"
          hwaccess: "hro"
          resval: 0
          fields: [
              {
                  bits: "3:0"
                  enum: [
                      { value: "0", name: "register", desc: "Connects the Pad to the internal configuration register."}
                      { value: "1", name: "port_qspi_qspi_csn", desc: "Connect port qspi_csn from port group qspi to this pad." }
                      { value: "2", name: "port_qspi_qspi_sck", desc: "Connect port qspi_sck from port group qspi to this pad." }
                      { value: "3", name: "port_qspi_qspi_sd0", desc: "Connect port qspi_sd0 from port group qspi to this pad." }
                      { value: "4", name: "port_qspi_qspi_sd1", desc: "Connect port qspi_sd1 from port group qspi to this pad." }
                      { value: "5", name: "port_qspi_qspi_sd2", desc: "Connect port qspi_sd2 from port group qspi to this pad." }
                      { value: "6", name: "port_qspi_qspi_sd3", desc: "Connect port qspi_sd3 from port group qspi to this pad." }
                      { value: "7", name: "port_sdio0_sdio_clk", desc: "Connect port sdio_clk from port group sdio0 to this pad." }
                      { value: "8", name: "port_sdio0_sdio_cmd", desc: "Connect port sdio_cmd from port group sdio0 to this pad." }
                      { value: "9", name: "port_sdio0_sdio_data0", desc: "Connect port sdio_data0 from port group sdio0 to this pad." }
                      { value: "10", name: "port_sdio0_sdio_data1", desc: "Connect port sdio_data1 from port group sdio0 to this pad." }
                      { value: "11", name: "port_sdio0_sdio_data2", desc: "Connect port sdio_data2 from port group sdio0 to this pad." }
                      { value: "12", name: "port_sdio0_sdio_data3", desc: "Connect port sdio_data3 from port group sdio0 to this pad." }
                  ]
              }
          ]
      }

      {
          name: PAD_IO_C_03_CFG
          desc: '''
            Pad signal configuration.
          '''
          swaccess: "rw"
          fields: [
            {
                bits: "0"
                name: chip2pad
                desc: '''
                     The signal that connects to the pads TX driver
                '''
                swaccess: "rw"
                hwaccess: "hro"
                resval: "0"
            },
            {
                bits: "1"
                name: oen
                desc: '''
                     Output enable signal, active low
                '''
                swaccess: "rw"
                hwaccess: "hro"
                resval: "1"
            },
          ]
      }

       {
          name: PAD_IO_C_03_MUX_SEL
          desc: '''
              Pad signal port multiplex selection for pad pad_io_c_03. The programmed value defines which port
              is connected to the pad.
          '''
          swaccess: "rw"
          hwaccess: "hro"
          resval: 0
          fields: [
              {
                  bits: "3:0"
                  enum: [
                      { value: "0", name: "register", desc: "Connects the Pad to the internal configuration register."}
                      { value: "1", name: "port_qspi_qspi_csn", desc: "Connect port qspi_csn from port group qspi to this pad." }
                      { value: "2", name: "port_qspi_qspi_sck", desc: "Connect port qspi_sck from port group qspi to this pad." }
                      { value: "3", name: "port_qspi_qspi_sd0", desc: "Connect port qspi_sd0 from port group qspi to this pad." }
                      { value: "4", name: "port_qspi_qspi_sd1", desc: "Connect port qspi_sd1 from port group qspi to this pad." }
                      { value: "5", name: "port_qspi_qspi_sd2", desc: "Connect port qspi_sd2 from port group qspi to this pad." }
                      { value: "6", name: "port_qspi_qspi_sd3", desc: "Connect port qspi_sd3 from port group qspi to this pad." }
                      { value: "7", name: "port_sdio0_sdio_clk", desc: "Connect port sdio_clk from port group sdio0 to this pad." }
                      { value: "8", name: "port_sdio0_sdio_cmd", desc: "Connect port sdio_cmd from port group sdio0 to this pad." }
                      { value: "9", name: "port_sdio0_sdio_data0", desc: "Connect port sdio_data0 from port group sdio0 to this pad." }
                      { value: "10", name: "port_sdio0_sdio_data1", desc: "Connect port sdio_data1 from port group sdio0 to this pad." }
                      { value: "11", name: "port_sdio0_sdio_data2", desc: "Connect port sdio_data2 from port group sdio0 to this pad." }
                      { value: "12", name: "port_sdio0_sdio_data3", desc: "Connect port sdio_data3 from port group sdio0 to this pad." }
                  ]
              }
          ]
      }

      {
          name: PAD_IO_C_04_CFG
          desc: '''
            Pad signal configuration.
          '''
          swaccess: "rw"
          fields: [
            {
                bits: "0"
                name: chip2pad
                desc: '''
                     The signal that connects to the pads TX driver
                '''
                swaccess: "rw"
                hwaccess: "hro"
                resval: "0"
            },
            {
                bits: "1"
                name: oen
                desc: '''
                     Output enable signal, active low
                '''
                swaccess: "rw"
                hwaccess: "hro"
                resval: "1"
            },
          ]
      }

       {
          name: PAD_IO_C_04_MUX_SEL
          desc: '''
              Pad signal port multiplex selection for pad pad_io_c_04. The programmed value defines which port
              is connected to the pad.
          '''
          swaccess: "rw"
          hwaccess: "hro"
          resval: 0
          fields: [
              {
                  bits: "3:0"
                  enum: [
                      { value: "0", name: "register", desc: "Connects the Pad to the internal configuration register."}
                      { value: "1", name: "port_qspi_qspi_csn", desc: "Connect port qspi_csn from port group qspi to this pad." }
                      { value: "2", name: "port_qspi_qspi_sck", desc: "Connect port qspi_sck from port group qspi to this pad." }
                      { value: "3", name: "port_qspi_qspi_sd0", desc: "Connect port qspi_sd0 from port group qspi to this pad." }
                      { value: "4", name: "port_qspi_qspi_sd1", desc: "Connect port qspi_sd1 from port group qspi to this pad." }
                      { value: "5", name: "port_qspi_qspi_sd2", desc: "Connect port qspi_sd2 from port group qspi to this pad." }
                      { value: "6", name: "port_qspi_qspi_sd3", desc: "Connect port qspi_sd3 from port group qspi to this pad." }
                      { value: "7", name: "port_sdio0_sdio_clk", desc: "Connect port sdio_clk from port group sdio0 to this pad." }
                      { value: "8", name: "port_sdio0_sdio_cmd", desc: "Connect port sdio_cmd from port group sdio0 to this pad." }
                      { value: "9", name: "port_sdio0_sdio_data0", desc: "Connect port sdio_data0 from port group sdio0 to this pad." }
                      { value: "10", name: "port_sdio0_sdio_data1", desc: "Connect port sdio_data1 from port group sdio0 to this pad." }
                      { value: "11", name: "port_sdio0_sdio_data2", desc: "Connect port sdio_data2 from port group sdio0 to this pad." }
                      { value: "12", name: "port_sdio0_sdio_data3", desc: "Connect port sdio_data3 from port group sdio0 to this pad." }
                  ]
              }
          ]
      }

      {
          name: PAD_IO_C_05_CFG
          desc: '''
            Pad signal configuration.
          '''
          swaccess: "rw"
          fields: [
            {
                bits: "0"
                name: chip2pad
                desc: '''
                     The signal that connects to the pads TX driver
                '''
                swaccess: "rw"
                hwaccess: "hro"
                resval: "0"
            },
            {
                bits: "1"
                name: oen
                desc: '''
                     Output enable signal, active low
                '''
                swaccess: "rw"
                hwaccess: "hro"
                resval: "1"
            },
          ]
      }

       {
          name: PAD_IO_C_05_MUX_SEL
          desc: '''
              Pad signal port multiplex selection for pad pad_io_c_05. The programmed value defines which port
              is connected to the pad.
          '''
          swaccess: "rw"
          hwaccess: "hro"
          resval: 0
          fields: [
              {
                  bits: "3:0"
                  enum: [
                      { value: "0", name: "register", desc: "Connects the Pad to the internal configuration register."}
                      { value: "1", name: "port_qspi_qspi_csn", desc: "Connect port qspi_csn from port group qspi to this pad." }
                      { value: "2", name: "port_qspi_qspi_sck", desc: "Connect port qspi_sck from port group qspi to this pad." }
                      { value: "3", name: "port_qspi_qspi_sd0", desc: "Connect port qspi_sd0 from port group qspi to this pad." }
                      { value: "4", name: "port_qspi_qspi_sd1", desc: "Connect port qspi_sd1 from port group qspi to this pad." }
                      { value: "5", name: "port_qspi_qspi_sd2", desc: "Connect port qspi_sd2 from port group qspi to this pad." }
                      { value: "6", name: "port_qspi_qspi_sd3", desc: "Connect port qspi_sd3 from port group qspi to this pad." }
                      { value: "7", name: "port_sdio0_sdio_clk", desc: "Connect port sdio_clk from port group sdio0 to this pad." }
                      { value: "8", name: "port_sdio0_sdio_cmd", desc: "Connect port sdio_cmd from port group sdio0 to this pad." }
                      { value: "9", name: "port_sdio0_sdio_data0", desc: "Connect port sdio_data0 from port group sdio0 to this pad." }
                      { value: "10", name: "port_sdio0_sdio_data1", desc: "Connect port sdio_data1 from port group sdio0 to this pad." }
                      { value: "11", name: "port_sdio0_sdio_data2", desc: "Connect port sdio_data2 from port group sdio0 to this pad." }
                      { value: "12", name: "port_sdio0_sdio_data3", desc: "Connect port sdio_data3 from port group sdio0 to this pad." }
                  ]
              }
          ]
      }

      {
          name: PAD_IO_C_06_CFG
          desc: '''
            Pad signal configuration.
          '''
          swaccess: "rw"
          fields: [
            {
                bits: "0"
                name: chip2pad
                desc: '''
                     The signal that connects to the pads TX driver
                '''
                swaccess: "rw"
                hwaccess: "hro"
                resval: "0"
            },
            {
                bits: "1"
                name: oen
                desc: '''
                     Output enable signal, active low
                '''
                swaccess: "rw"
                hwaccess: "hro"
                resval: "1"
            },
          ]
      }

       {
          name: PAD_IO_C_06_MUX_SEL
          desc: '''
              Pad signal port multiplex selection for pad pad_io_c_06. The programmed value defines which port
              is connected to the pad.
          '''
          swaccess: "rw"
          hwaccess: "hro"
          resval: 0
          fields: [
              {
                  bits: "3:0"
                  enum: [
                      { value: "0", name: "register", desc: "Connects the Pad to the internal configuration register."}
                      { value: "1", name: "port_qspi_qspi_csn", desc: "Connect port qspi_csn from port group qspi to this pad." }
                      { value: "2", name: "port_qspi_qspi_sck", desc: "Connect port qspi_sck from port group qspi to this pad." }
                      { value: "3", name: "port_qspi_qspi_sd0", desc: "Connect port qspi_sd0 from port group qspi to this pad." }
                      { value: "4", name: "port_qspi_qspi_sd1", desc: "Connect port qspi_sd1 from port group qspi to this pad." }
                      { value: "5", name: "port_qspi_qspi_sd2", desc: "Connect port qspi_sd2 from port group qspi to this pad." }
                      { value: "6", name: "port_qspi_qspi_sd3", desc: "Connect port qspi_sd3 from port group qspi to this pad." }
                      { value: "7", name: "port_sdio0_sdio_clk", desc: "Connect port sdio_clk from port group sdio0 to this pad." }
                      { value: "8", name: "port_sdio0_sdio_cmd", desc: "Connect port sdio_cmd from port group sdio0 to this pad." }
                      { value: "9", name: "port_sdio0_sdio_data0", desc: "Connect port sdio_data0 from port group sdio0 to this pad." }
                      { value: "10", name: "port_sdio0_sdio_data1", desc: "Connect port sdio_data1 from port group sdio0 to this pad." }
                      { value: "11", name: "port_sdio0_sdio_data2", desc: "Connect port sdio_data2 from port group sdio0 to this pad." }
                      { value: "12", name: "port_sdio0_sdio_data3", desc: "Connect port sdio_data3 from port group sdio0 to this pad." }
                  ]
              }
          ]
      }

      {
          name: PAD_IO_C_07_CFG
          desc: '''
            Pad signal configuration.
          '''
          swaccess: "rw"
          fields: [
            {
                bits: "0"
                name: chip2pad
                desc: '''
                     The signal that connects to the pads TX driver
                '''
                swaccess: "rw"
                hwaccess: "hro"
                resval: "0"
            },
            {
                bits: "1"
                name: oen
                desc: '''
                     Output enable signal, active low
                '''
                swaccess: "rw"
                hwaccess: "hro"
                resval: "1"
            },
          ]
      }

       {
          name: PAD_IO_C_07_MUX_SEL
          desc: '''
              Pad signal port multiplex selection for pad pad_io_c_07. The programmed value defines which port
              is connected to the pad.
          '''
          swaccess: "rw"
          hwaccess: "hro"
          resval: 0
          fields: [
              {
                  bits: "3:0"
                  enum: [
                      { value: "0", name: "register", desc: "Connects the Pad to the internal configuration register."}
                      { value: "1", name: "port_qspi_qspi_csn", desc: "Connect port qspi_csn from port group qspi to this pad." }
                      { value: "2", name: "port_qspi_qspi_sck", desc: "Connect port qspi_sck from port group qspi to this pad." }
                      { value: "3", name: "port_qspi_qspi_sd0", desc: "Connect port qspi_sd0 from port group qspi to this pad." }
                      { value: "4", name: "port_qspi_qspi_sd1", desc: "Connect port qspi_sd1 from port group qspi to this pad." }
                      { value: "5", name: "port_qspi_qspi_sd2", desc: "Connect port qspi_sd2 from port group qspi to this pad." }
                      { value: "6", name: "port_qspi_qspi_sd3", desc: "Connect port qspi_sd3 from port group qspi to this pad." }
                      { value: "7", name: "port_sdio0_sdio_clk", desc: "Connect port sdio_clk from port group sdio0 to this pad." }
                      { value: "8", name: "port_sdio0_sdio_cmd", desc: "Connect port sdio_cmd from port group sdio0 to this pad." }
                      { value: "9", name: "port_sdio0_sdio_data0", desc: "Connect port sdio_data0 from port group sdio0 to this pad." }
                      { value: "10", name: "port_sdio0_sdio_data1", desc: "Connect port sdio_data1 from port group sdio0 to this pad." }
                      { value: "11", name: "port_sdio0_sdio_data2", desc: "Connect port sdio_data2 from port group sdio0 to this pad." }
                      { value: "12", name: "port_sdio0_sdio_data3", desc: "Connect port sdio_data3 from port group sdio0 to this pad." }
                  ]
              }
          ]
      }

      {
          name: PAD_IO_C_08_CFG
          desc: '''
            Pad signal configuration.
          '''
          swaccess: "rw"
          fields: [
            {
                bits: "0"
                name: chip2pad
                desc: '''
                     The signal that connects to the pads TX driver
                '''
                swaccess: "rw"
                hwaccess: "hro"
                resval: "0"
            },
            {
                bits: "1"
                name: oen
                desc: '''
                     Output enable signal, active low
                '''
                swaccess: "rw"
                hwaccess: "hro"
                resval: "1"
            },
          ]
      }

       {
          name: PAD_IO_C_08_MUX_SEL
          desc: '''
              Pad signal port multiplex selection for pad pad_io_c_08. The programmed value defines which port
              is connected to the pad.
          '''
          swaccess: "rw"
          hwaccess: "hro"
          resval: 0
          fields: [
              {
                  bits: "3:0"
                  enum: [
                      { value: "0", name: "register", desc: "Connects the Pad to the internal configuration register."}
                      { value: "1", name: "port_qspi_qspi_csn", desc: "Connect port qspi_csn from port group qspi to this pad." }
                      { value: "2", name: "port_qspi_qspi_sck", desc: "Connect port qspi_sck from port group qspi to this pad." }
                      { value: "3", name: "port_qspi_qspi_sd0", desc: "Connect port qspi_sd0 from port group qspi to this pad." }
                      { value: "4", name: "port_qspi_qspi_sd1", desc: "Connect port qspi_sd1 from port group qspi to this pad." }
                      { value: "5", name: "port_qspi_qspi_sd2", desc: "Connect port qspi_sd2 from port group qspi to this pad." }
                      { value: "6", name: "port_qspi_qspi_sd3", desc: "Connect port qspi_sd3 from port group qspi to this pad." }
                      { value: "7", name: "port_sdio0_sdio_clk", desc: "Connect port sdio_clk from port group sdio0 to this pad." }
                      { value: "8", name: "port_sdio0_sdio_cmd", desc: "Connect port sdio_cmd from port group sdio0 to this pad." }
                      { value: "9", name: "port_sdio0_sdio_data0", desc: "Connect port sdio_data0 from port group sdio0 to this pad." }
                      { value: "10", name: "port_sdio0_sdio_data1", desc: "Connect port sdio_data1 from port group sdio0 to this pad." }
                      { value: "11", name: "port_sdio0_sdio_data2", desc: "Connect port sdio_data2 from port group sdio0 to this pad." }
                      { value: "12", name: "port_sdio0_sdio_data3", desc: "Connect port sdio_data3 from port group sdio0 to this pad." }
                  ]
              }
          ]
      }

      {
          name: PAD_IO_C_09_CFG
          desc: '''
            Pad signal configuration.
          '''
          swaccess: "rw"
          fields: [
            {
                bits: "0"
                name: chip2pad
                desc: '''
                     The signal that connects to the pads TX driver
                '''
                swaccess: "rw"
                hwaccess: "hro"
                resval: "0"
            },
            {
                bits: "1"
                name: oen
                desc: '''
                     Output enable signal, active low
                '''
                swaccess: "rw"
                hwaccess: "hro"
                resval: "1"
            },
          ]
      }

       {
          name: PAD_IO_C_09_MUX_SEL
          desc: '''
              Pad signal port multiplex selection for pad pad_io_c_09. The programmed value defines which port
              is connected to the pad.
          '''
          swaccess: "rw"
          hwaccess: "hro"
          resval: 0
          fields: [
              {
                  bits: "3:0"
                  enum: [
                      { value: "0", name: "register", desc: "Connects the Pad to the internal configuration register."}
                      { value: "1", name: "port_qspi_qspi_csn", desc: "Connect port qspi_csn from port group qspi to this pad." }
                      { value: "2", name: "port_qspi_qspi_sck", desc: "Connect port qspi_sck from port group qspi to this pad." }
                      { value: "3", name: "port_qspi_qspi_sd0", desc: "Connect port qspi_sd0 from port group qspi to this pad." }
                      { value: "4", name: "port_qspi_qspi_sd1", desc: "Connect port qspi_sd1 from port group qspi to this pad." }
                      { value: "5", name: "port_qspi_qspi_sd2", desc: "Connect port qspi_sd2 from port group qspi to this pad." }
                      { value: "6", name: "port_qspi_qspi_sd3", desc: "Connect port qspi_sd3 from port group qspi to this pad." }
                      { value: "7", name: "port_sdio0_sdio_clk", desc: "Connect port sdio_clk from port group sdio0 to this pad." }
                      { value: "8", name: "port_sdio0_sdio_cmd", desc: "Connect port sdio_cmd from port group sdio0 to this pad." }
                      { value: "9", name: "port_sdio0_sdio_data0", desc: "Connect port sdio_data0 from port group sdio0 to this pad." }
                      { value: "10", name: "port_sdio0_sdio_data1", desc: "Connect port sdio_data1 from port group sdio0 to this pad." }
                      { value: "11", name: "port_sdio0_sdio_data2", desc: "Connect port sdio_data2 from port group sdio0 to this pad." }
                      { value: "12", name: "port_sdio0_sdio_data3", desc: "Connect port sdio_data3 from port group sdio0 to this pad." }
                  ]
              }
          ]
      }

      {
          name: PAD_IO_C_10_CFG
          desc: '''
            Pad signal configuration.
          '''
          swaccess: "rw"
          fields: [
            {
                bits: "0"
                name: chip2pad
                desc: '''
                     The signal that connects to the pads TX driver
                '''
                swaccess: "rw"
                hwaccess: "hro"
                resval: "0"
            },
            {
                bits: "1"
                name: oen
                desc: '''
                     Output enable signal, active low
                '''
                swaccess: "rw"
                hwaccess: "hro"
                resval: "1"
            },
          ]
      }

       {
          name: PAD_IO_C_10_MUX_SEL
          desc: '''
              Pad signal port multiplex selection for pad pad_io_c_10. The programmed value defines which port
              is connected to the pad.
          '''
          swaccess: "rw"
          hwaccess: "hro"
          resval: 0
          fields: [
              {
                  bits: "3:0"
                  enum: [
                      { value: "0", name: "register", desc: "Connects the Pad to the internal configuration register."}
                      { value: "1", name: "port_qspi_qspi_csn", desc: "Connect port qspi_csn from port group qspi to this pad." }
                      { value: "2", name: "port_qspi_qspi_sck", desc: "Connect port qspi_sck from port group qspi to this pad." }
                      { value: "3", name: "port_qspi_qspi_sd0", desc: "Connect port qspi_sd0 from port group qspi to this pad." }
                      { value: "4", name: "port_qspi_qspi_sd1", desc: "Connect port qspi_sd1 from port group qspi to this pad." }
                      { value: "5", name: "port_qspi_qspi_sd2", desc: "Connect port qspi_sd2 from port group qspi to this pad." }
                      { value: "6", name: "port_qspi_qspi_sd3", desc: "Connect port qspi_sd3 from port group qspi to this pad." }
                      { value: "7", name: "port_sdio0_sdio_clk", desc: "Connect port sdio_clk from port group sdio0 to this pad." }
                      { value: "8", name: "port_sdio0_sdio_cmd", desc: "Connect port sdio_cmd from port group sdio0 to this pad." }
                      { value: "9", name: "port_sdio0_sdio_data0", desc: "Connect port sdio_data0 from port group sdio0 to this pad." }
                      { value: "10", name: "port_sdio0_sdio_data1", desc: "Connect port sdio_data1 from port group sdio0 to this pad." }
                      { value: "11", name: "port_sdio0_sdio_data2", desc: "Connect port sdio_data2 from port group sdio0 to this pad." }
                      { value: "12", name: "port_sdio0_sdio_data3", desc: "Connect port sdio_data3 from port group sdio0 to this pad." }
                  ]
              }
          ]
      }

      {
          name: PAD_IO_C_11_CFG
          desc: '''
            Pad signal configuration.
          '''
          swaccess: "rw"
          fields: [
            {
                bits: "0"
                name: chip2pad
                desc: '''
                     The signal that connects to the pads TX driver
                '''
                swaccess: "rw"
                hwaccess: "hro"
                resval: "0"
            },
            {
                bits: "1"
                name: oen
                desc: '''
                     Output enable signal, active low
                '''
                swaccess: "rw"
                hwaccess: "hro"
                resval: "1"
            },
          ]
      }

       {
          name: PAD_IO_C_11_MUX_SEL
          desc: '''
              Pad signal port multiplex selection for pad pad_io_c_11. The programmed value defines which port
              is connected to the pad.
          '''
          swaccess: "rw"
          hwaccess: "hro"
          resval: 0
          fields: [
              {
                  bits: "3:0"
                  enum: [
                      { value: "0", name: "register", desc: "Connects the Pad to the internal configuration register."}
                      { value: "1", name: "port_qspi_qspi_csn", desc: "Connect port qspi_csn from port group qspi to this pad." }
                      { value: "2", name: "port_qspi_qspi_sck", desc: "Connect port qspi_sck from port group qspi to this pad." }
                      { value: "3", name: "port_qspi_qspi_sd0", desc: "Connect port qspi_sd0 from port group qspi to this pad." }
                      { value: "4", name: "port_qspi_qspi_sd1", desc: "Connect port qspi_sd1 from port group qspi to this pad." }
                      { value: "5", name: "port_qspi_qspi_sd2", desc: "Connect port qspi_sd2 from port group qspi to this pad." }
                      { value: "6", name: "port_qspi_qspi_sd3", desc: "Connect port qspi_sd3 from port group qspi to this pad." }
                      { value: "7", name: "port_sdio0_sdio_clk", desc: "Connect port sdio_clk from port group sdio0 to this pad." }
                      { value: "8", name: "port_sdio0_sdio_cmd", desc: "Connect port sdio_cmd from port group sdio0 to this pad." }
                      { value: "9", name: "port_sdio0_sdio_data0", desc: "Connect port sdio_data0 from port group sdio0 to this pad." }
                      { value: "10", name: "port_sdio0_sdio_data1", desc: "Connect port sdio_data1 from port group sdio0 to this pad." }
                      { value: "11", name: "port_sdio0_sdio_data2", desc: "Connect port sdio_data2 from port group sdio0 to this pad." }
                      { value: "12", name: "port_sdio0_sdio_data3", desc: "Connect port sdio_data3 from port group sdio0 to this pad." }
                  ]
              }
          ]
      }

      {
          name: PAD_IO_C_12_CFG
          desc: '''
            Pad signal configuration.
          '''
          swaccess: "rw"
          fields: [
            {
                bits: "0"
                name: chip2pad
                desc: '''
                     The signal that connects to the pads TX driver
                '''
                swaccess: "rw"
                hwaccess: "hro"
                resval: "0"
            },
            {
                bits: "1"
                name: oen
                desc: '''
                     Output enable signal, active low
                '''
                swaccess: "rw"
                hwaccess: "hro"
                resval: "1"
            },
          ]
      }

       {
          name: PAD_IO_C_12_MUX_SEL
          desc: '''
              Pad signal port multiplex selection for pad pad_io_c_12. The programmed value defines which port
              is connected to the pad.
          '''
          swaccess: "rw"
          hwaccess: "hro"
          resval: 0
          fields: [
              {
                  bits: "3:0"
                  enum: [
                      { value: "0", name: "register", desc: "Connects the Pad to the internal configuration register."}
                      { value: "1", name: "port_qspi_qspi_csn", desc: "Connect port qspi_csn from port group qspi to this pad." }
                      { value: "2", name: "port_qspi_qspi_sck", desc: "Connect port qspi_sck from port group qspi to this pad." }
                      { value: "3", name: "port_qspi_qspi_sd0", desc: "Connect port qspi_sd0 from port group qspi to this pad." }
                      { value: "4", name: "port_qspi_qspi_sd1", desc: "Connect port qspi_sd1 from port group qspi to this pad." }
                      { value: "5", name: "port_qspi_qspi_sd2", desc: "Connect port qspi_sd2 from port group qspi to this pad." }
                      { value: "6", name: "port_qspi_qspi_sd3", desc: "Connect port qspi_sd3 from port group qspi to this pad." }
                      { value: "7", name: "port_sdio0_sdio_clk", desc: "Connect port sdio_clk from port group sdio0 to this pad." }
                      { value: "8", name: "port_sdio0_sdio_cmd", desc: "Connect port sdio_cmd from port group sdio0 to this pad." }
                      { value: "9", name: "port_sdio0_sdio_data0", desc: "Connect port sdio_data0 from port group sdio0 to this pad." }
                      { value: "10", name: "port_sdio0_sdio_data1", desc: "Connect port sdio_data1 from port group sdio0 to this pad." }
                      { value: "11", name: "port_sdio0_sdio_data2", desc: "Connect port sdio_data2 from port group sdio0 to this pad." }
                      { value: "12", name: "port_sdio0_sdio_data3", desc: "Connect port sdio_data3 from port group sdio0 to this pad." }
                  ]
              }
          ]
      }

      {
          name: PAD_IO_C_13_CFG
          desc: '''
            Pad signal configuration.
          '''
          swaccess: "rw"
          fields: [
            {
                bits: "0"
                name: chip2pad
                desc: '''
                     The signal that connects to the pads TX driver
                '''
                swaccess: "rw"
                hwaccess: "hro"
                resval: "0"
            },
            {
                bits: "1"
                name: oen
                desc: '''
                     Output enable signal, active low
                '''
                swaccess: "rw"
                hwaccess: "hro"
                resval: "1"
            },
          ]
      }

       {
          name: PAD_IO_C_13_MUX_SEL
          desc: '''
              Pad signal port multiplex selection for pad pad_io_c_13. The programmed value defines which port
              is connected to the pad.
          '''
          swaccess: "rw"
          hwaccess: "hro"
          resval: 0
          fields: [
              {
                  bits: "3:0"
                  enum: [
                      { value: "0", name: "register", desc: "Connects the Pad to the internal configuration register."}
                      { value: "1", name: "port_qspi_qspi_csn", desc: "Connect port qspi_csn from port group qspi to this pad." }
                      { value: "2", name: "port_qspi_qspi_sck", desc: "Connect port qspi_sck from port group qspi to this pad." }
                      { value: "3", name: "port_qspi_qspi_sd0", desc: "Connect port qspi_sd0 from port group qspi to this pad." }
                      { value: "4", name: "port_qspi_qspi_sd1", desc: "Connect port qspi_sd1 from port group qspi to this pad." }
                      { value: "5", name: "port_qspi_qspi_sd2", desc: "Connect port qspi_sd2 from port group qspi to this pad." }
                      { value: "6", name: "port_qspi_qspi_sd3", desc: "Connect port qspi_sd3 from port group qspi to this pad." }
                      { value: "7", name: "port_sdio0_sdio_clk", desc: "Connect port sdio_clk from port group sdio0 to this pad." }
                      { value: "8", name: "port_sdio0_sdio_cmd", desc: "Connect port sdio_cmd from port group sdio0 to this pad." }
                      { value: "9", name: "port_sdio0_sdio_data0", desc: "Connect port sdio_data0 from port group sdio0 to this pad." }
                      { value: "10", name: "port_sdio0_sdio_data1", desc: "Connect port sdio_data1 from port group sdio0 to this pad." }
                      { value: "11", name: "port_sdio0_sdio_data2", desc: "Connect port sdio_data2 from port group sdio0 to this pad." }
                      { value: "12", name: "port_sdio0_sdio_data3", desc: "Connect port sdio_data3 from port group sdio0 to this pad." }
                  ]
              }
          ]
      }

      {
          name: PAD_IO_D_00_CFG
          desc: '''
            Pad signal configuration.
          '''
          swaccess: "rw"
          fields: [
            {
                bits: "0"
                name: chip2pad
                desc: '''
                     The signal that connects to the pads TX driver
                '''
                swaccess: "rw"
                hwaccess: "hro"
                resval: "0"
            },
            {
                bits: "1"
                name: oen
                desc: '''
                     Output enable signal, active low
                '''
                swaccess: "rw"
                hwaccess: "hro"
                resval: "1"
            },
          ]
      }

       {
          name: PAD_IO_D_00_MUX_SEL
          desc: '''
              Pad signal port multiplex selection for pad pad_io_d_00. The programmed value defines which port
              is connected to the pad.
          '''
          swaccess: "rw"
          hwaccess: "hro"
          resval: 0
          fields: [
              {
                  bits: "4:0"
                  enum: [
                      { value: "0", name: "register", desc: "Connects the Pad to the internal configuration register."}
                      { value: "1", name: "port_uart0_uart_rx", desc: "Connect port uart_rx from port group uart0 to this pad." }
                      { value: "2", name: "port_uart0_uart_tx", desc: "Connect port uart_tx from port group uart0 to this pad." }
                      { value: "3", name: "port_uart1_uart_rx", desc: "Connect port uart_rx from port group uart1 to this pad." }
                      { value: "4", name: "port_uart1_uart_tx", desc: "Connect port uart_tx from port group uart1 to this pad." }
                      { value: "5", name: "port_uart_cf0_uart_cts", desc: "Connect port uart_cts from port group uart_cf0 to this pad." }
                      { value: "6", name: "port_uart_cf0_uart_rts", desc: "Connect port uart_rts from port group uart_cf0 to this pad." }
                      { value: "7", name: "port_uart_cf0_uart_rx", desc: "Connect port uart_rx from port group uart_cf0 to this pad." }
                      { value: "8", name: "port_uart_cf0_uart_tx", desc: "Connect port uart_tx from port group uart_cf0 to this pad." }
                      { value: "9", name: "port_uart_cf1_uart_cts", desc: "Connect port uart_cts from port group uart_cf1 to this pad." }
                      { value: "10", name: "port_uart_cf1_uart_rts", desc: "Connect port uart_rts from port group uart_cf1 to this pad." }
                      { value: "11", name: "port_uart_cf1_uart_rx", desc: "Connect port uart_rx from port group uart_cf1 to this pad." }
                      { value: "12", name: "port_uart_cf1_uart_tx", desc: "Connect port uart_tx from port group uart_cf1 to this pad." }
                      { value: "13", name: "port_uart_cf2_uart_cts", desc: "Connect port uart_cts from port group uart_cf2 to this pad." }
                      { value: "14", name: "port_uart_cf2_uart_rts", desc: "Connect port uart_rts from port group uart_cf2 to this pad." }
                      { value: "15", name: "port_uart_cf2_uart_rx", desc: "Connect port uart_rx from port group uart_cf2 to this pad." }
                      { value: "16", name: "port_uart_cf2_uart_tx", desc: "Connect port uart_tx from port group uart_cf2 to this pad." }
                  ]
              }
          ]
      }

      {
          name: PAD_IO_D_01_CFG
          desc: '''
            Pad signal configuration.
          '''
          swaccess: "rw"
          fields: [
            {
                bits: "0"
                name: chip2pad
                desc: '''
                     The signal that connects to the pads TX driver
                '''
                swaccess: "rw"
                hwaccess: "hro"
                resval: "0"
            },
            {
                bits: "1"
                name: oen
                desc: '''
                     Output enable signal, active low
                '''
                swaccess: "rw"
                hwaccess: "hro"
                resval: "1"
            },
          ]
      }

       {
          name: PAD_IO_D_01_MUX_SEL
          desc: '''
              Pad signal port multiplex selection for pad pad_io_d_01. The programmed value defines which port
              is connected to the pad.
          '''
          swaccess: "rw"
          hwaccess: "hro"
          resval: 0
          fields: [
              {
                  bits: "4:0"
                  enum: [
                      { value: "0", name: "register", desc: "Connects the Pad to the internal configuration register."}
                      { value: "1", name: "port_uart0_uart_rx", desc: "Connect port uart_rx from port group uart0 to this pad." }
                      { value: "2", name: "port_uart0_uart_tx", desc: "Connect port uart_tx from port group uart0 to this pad." }
                      { value: "3", name: "port_uart1_uart_rx", desc: "Connect port uart_rx from port group uart1 to this pad." }
                      { value: "4", name: "port_uart1_uart_tx", desc: "Connect port uart_tx from port group uart1 to this pad." }
                      { value: "5", name: "port_uart_cf0_uart_cts", desc: "Connect port uart_cts from port group uart_cf0 to this pad." }
                      { value: "6", name: "port_uart_cf0_uart_rts", desc: "Connect port uart_rts from port group uart_cf0 to this pad." }
                      { value: "7", name: "port_uart_cf0_uart_rx", desc: "Connect port uart_rx from port group uart_cf0 to this pad." }
                      { value: "8", name: "port_uart_cf0_uart_tx", desc: "Connect port uart_tx from port group uart_cf0 to this pad." }
                      { value: "9", name: "port_uart_cf1_uart_cts", desc: "Connect port uart_cts from port group uart_cf1 to this pad." }
                      { value: "10", name: "port_uart_cf1_uart_rts", desc: "Connect port uart_rts from port group uart_cf1 to this pad." }
                      { value: "11", name: "port_uart_cf1_uart_rx", desc: "Connect port uart_rx from port group uart_cf1 to this pad." }
                      { value: "12", name: "port_uart_cf1_uart_tx", desc: "Connect port uart_tx from port group uart_cf1 to this pad." }
                      { value: "13", name: "port_uart_cf2_uart_cts", desc: "Connect port uart_cts from port group uart_cf2 to this pad." }
                      { value: "14", name: "port_uart_cf2_uart_rts", desc: "Connect port uart_rts from port group uart_cf2 to this pad." }
                      { value: "15", name: "port_uart_cf2_uart_rx", desc: "Connect port uart_rx from port group uart_cf2 to this pad." }
                      { value: "16", name: "port_uart_cf2_uart_tx", desc: "Connect port uart_tx from port group uart_cf2 to this pad." }
                  ]
              }
          ]
      }

      {
          name: PAD_IO_D_02_CFG
          desc: '''
            Pad signal configuration.
          '''
          swaccess: "rw"
          fields: [
            {
                bits: "0"
                name: chip2pad
                desc: '''
                     The signal that connects to the pads TX driver
                '''
                swaccess: "rw"
                hwaccess: "hro"
                resval: "0"
            },
            {
                bits: "1"
                name: oen
                desc: '''
                     Output enable signal, active low
                '''
                swaccess: "rw"
                hwaccess: "hro"
                resval: "1"
            },
          ]
      }

       {
          name: PAD_IO_D_02_MUX_SEL
          desc: '''
              Pad signal port multiplex selection for pad pad_io_d_02. The programmed value defines which port
              is connected to the pad.
          '''
          swaccess: "rw"
          hwaccess: "hro"
          resval: 0
          fields: [
              {
                  bits: "4:0"
                  enum: [
                      { value: "0", name: "register", desc: "Connects the Pad to the internal configuration register."}
                      { value: "1", name: "port_uart0_uart_rx", desc: "Connect port uart_rx from port group uart0 to this pad." }
                      { value: "2", name: "port_uart0_uart_tx", desc: "Connect port uart_tx from port group uart0 to this pad." }
                      { value: "3", name: "port_uart1_uart_rx", desc: "Connect port uart_rx from port group uart1 to this pad." }
                      { value: "4", name: "port_uart1_uart_tx", desc: "Connect port uart_tx from port group uart1 to this pad." }
                      { value: "5", name: "port_uart_cf0_uart_cts", desc: "Connect port uart_cts from port group uart_cf0 to this pad." }
                      { value: "6", name: "port_uart_cf0_uart_rts", desc: "Connect port uart_rts from port group uart_cf0 to this pad." }
                      { value: "7", name: "port_uart_cf0_uart_rx", desc: "Connect port uart_rx from port group uart_cf0 to this pad." }
                      { value: "8", name: "port_uart_cf0_uart_tx", desc: "Connect port uart_tx from port group uart_cf0 to this pad." }
                      { value: "9", name: "port_uart_cf1_uart_cts", desc: "Connect port uart_cts from port group uart_cf1 to this pad." }
                      { value: "10", name: "port_uart_cf1_uart_rts", desc: "Connect port uart_rts from port group uart_cf1 to this pad." }
                      { value: "11", name: "port_uart_cf1_uart_rx", desc: "Connect port uart_rx from port group uart_cf1 to this pad." }
                      { value: "12", name: "port_uart_cf1_uart_tx", desc: "Connect port uart_tx from port group uart_cf1 to this pad." }
                      { value: "13", name: "port_uart_cf2_uart_cts", desc: "Connect port uart_cts from port group uart_cf2 to this pad." }
                      { value: "14", name: "port_uart_cf2_uart_rts", desc: "Connect port uart_rts from port group uart_cf2 to this pad." }
                      { value: "15", name: "port_uart_cf2_uart_rx", desc: "Connect port uart_rx from port group uart_cf2 to this pad." }
                      { value: "16", name: "port_uart_cf2_uart_tx", desc: "Connect port uart_tx from port group uart_cf2 to this pad." }
                  ]
              }
          ]
      }

      {
          name: PAD_IO_D_03_CFG
          desc: '''
            Pad signal configuration.
          '''
          swaccess: "rw"
          fields: [
            {
                bits: "0"
                name: chip2pad
                desc: '''
                     The signal that connects to the pads TX driver
                '''
                swaccess: "rw"
                hwaccess: "hro"
                resval: "0"
            },
            {
                bits: "1"
                name: oen
                desc: '''
                     Output enable signal, active low
                '''
                swaccess: "rw"
                hwaccess: "hro"
                resval: "1"
            },
          ]
      }

       {
          name: PAD_IO_D_03_MUX_SEL
          desc: '''
              Pad signal port multiplex selection for pad pad_io_d_03. The programmed value defines which port
              is connected to the pad.
          '''
          swaccess: "rw"
          hwaccess: "hro"
          resval: 0
          fields: [
              {
                  bits: "4:0"
                  enum: [
                      { value: "0", name: "register", desc: "Connects the Pad to the internal configuration register."}
                      { value: "1", name: "port_uart0_uart_rx", desc: "Connect port uart_rx from port group uart0 to this pad." }
                      { value: "2", name: "port_uart0_uart_tx", desc: "Connect port uart_tx from port group uart0 to this pad." }
                      { value: "3", name: "port_uart1_uart_rx", desc: "Connect port uart_rx from port group uart1 to this pad." }
                      { value: "4", name: "port_uart1_uart_tx", desc: "Connect port uart_tx from port group uart1 to this pad." }
                      { value: "5", name: "port_uart_cf0_uart_cts", desc: "Connect port uart_cts from port group uart_cf0 to this pad." }
                      { value: "6", name: "port_uart_cf0_uart_rts", desc: "Connect port uart_rts from port group uart_cf0 to this pad." }
                      { value: "7", name: "port_uart_cf0_uart_rx", desc: "Connect port uart_rx from port group uart_cf0 to this pad." }
                      { value: "8", name: "port_uart_cf0_uart_tx", desc: "Connect port uart_tx from port group uart_cf0 to this pad." }
                      { value: "9", name: "port_uart_cf1_uart_cts", desc: "Connect port uart_cts from port group uart_cf1 to this pad." }
                      { value: "10", name: "port_uart_cf1_uart_rts", desc: "Connect port uart_rts from port group uart_cf1 to this pad." }
                      { value: "11", name: "port_uart_cf1_uart_rx", desc: "Connect port uart_rx from port group uart_cf1 to this pad." }
                      { value: "12", name: "port_uart_cf1_uart_tx", desc: "Connect port uart_tx from port group uart_cf1 to this pad." }
                      { value: "13", name: "port_uart_cf2_uart_cts", desc: "Connect port uart_cts from port group uart_cf2 to this pad." }
                      { value: "14", name: "port_uart_cf2_uart_rts", desc: "Connect port uart_rts from port group uart_cf2 to this pad." }
                      { value: "15", name: "port_uart_cf2_uart_rx", desc: "Connect port uart_rx from port group uart_cf2 to this pad." }
                      { value: "16", name: "port_uart_cf2_uart_tx", desc: "Connect port uart_tx from port group uart_cf2 to this pad." }
                  ]
              }
          ]
      }

      {
          name: PAD_IO_D_04_CFG
          desc: '''
            Pad signal configuration.
          '''
          swaccess: "rw"
          fields: [
            {
                bits: "0"
                name: chip2pad
                desc: '''
                     The signal that connects to the pads TX driver
                '''
                swaccess: "rw"
                hwaccess: "hro"
                resval: "0"
            },
            {
                bits: "1"
                name: oen
                desc: '''
                     Output enable signal, active low
                '''
                swaccess: "rw"
                hwaccess: "hro"
                resval: "1"
            },
          ]
      }

       {
          name: PAD_IO_D_04_MUX_SEL
          desc: '''
              Pad signal port multiplex selection for pad pad_io_d_04. The programmed value defines which port
              is connected to the pad.
          '''
          swaccess: "rw"
          hwaccess: "hro"
          resval: 0
          fields: [
              {
                  bits: "4:0"
                  enum: [
                      { value: "0", name: "register", desc: "Connects the Pad to the internal configuration register."}
                      { value: "1", name: "port_uart0_uart_rx", desc: "Connect port uart_rx from port group uart0 to this pad." }
                      { value: "2", name: "port_uart0_uart_tx", desc: "Connect port uart_tx from port group uart0 to this pad." }
                      { value: "3", name: "port_uart1_uart_rx", desc: "Connect port uart_rx from port group uart1 to this pad." }
                      { value: "4", name: "port_uart1_uart_tx", desc: "Connect port uart_tx from port group uart1 to this pad." }
                      { value: "5", name: "port_uart_cf0_uart_cts", desc: "Connect port uart_cts from port group uart_cf0 to this pad." }
                      { value: "6", name: "port_uart_cf0_uart_rts", desc: "Connect port uart_rts from port group uart_cf0 to this pad." }
                      { value: "7", name: "port_uart_cf0_uart_rx", desc: "Connect port uart_rx from port group uart_cf0 to this pad." }
                      { value: "8", name: "port_uart_cf0_uart_tx", desc: "Connect port uart_tx from port group uart_cf0 to this pad." }
                      { value: "9", name: "port_uart_cf1_uart_cts", desc: "Connect port uart_cts from port group uart_cf1 to this pad." }
                      { value: "10", name: "port_uart_cf1_uart_rts", desc: "Connect port uart_rts from port group uart_cf1 to this pad." }
                      { value: "11", name: "port_uart_cf1_uart_rx", desc: "Connect port uart_rx from port group uart_cf1 to this pad." }
                      { value: "12", name: "port_uart_cf1_uart_tx", desc: "Connect port uart_tx from port group uart_cf1 to this pad." }
                      { value: "13", name: "port_uart_cf2_uart_cts", desc: "Connect port uart_cts from port group uart_cf2 to this pad." }
                      { value: "14", name: "port_uart_cf2_uart_rts", desc: "Connect port uart_rts from port group uart_cf2 to this pad." }
                      { value: "15", name: "port_uart_cf2_uart_rx", desc: "Connect port uart_rx from port group uart_cf2 to this pad." }
                      { value: "16", name: "port_uart_cf2_uart_tx", desc: "Connect port uart_tx from port group uart_cf2 to this pad." }
                  ]
              }
          ]
      }

      {
          name: PAD_IO_D_05_CFG
          desc: '''
            Pad signal configuration.
          '''
          swaccess: "rw"
          fields: [
            {
                bits: "0"
                name: chip2pad
                desc: '''
                     The signal that connects to the pads TX driver
                '''
                swaccess: "rw"
                hwaccess: "hro"
                resval: "0"
            },
            {
                bits: "1"
                name: oen
                desc: '''
                     Output enable signal, active low
                '''
                swaccess: "rw"
                hwaccess: "hro"
                resval: "1"
            },
          ]
      }

       {
          name: PAD_IO_D_05_MUX_SEL
          desc: '''
              Pad signal port multiplex selection for pad pad_io_d_05. The programmed value defines which port
              is connected to the pad.
          '''
          swaccess: "rw"
          hwaccess: "hro"
          resval: 0
          fields: [
              {
                  bits: "4:0"
                  enum: [
                      { value: "0", name: "register", desc: "Connects the Pad to the internal configuration register."}
                      { value: "1", name: "port_uart0_uart_rx", desc: "Connect port uart_rx from port group uart0 to this pad." }
                      { value: "2", name: "port_uart0_uart_tx", desc: "Connect port uart_tx from port group uart0 to this pad." }
                      { value: "3", name: "port_uart1_uart_rx", desc: "Connect port uart_rx from port group uart1 to this pad." }
                      { value: "4", name: "port_uart1_uart_tx", desc: "Connect port uart_tx from port group uart1 to this pad." }
                      { value: "5", name: "port_uart_cf0_uart_cts", desc: "Connect port uart_cts from port group uart_cf0 to this pad." }
                      { value: "6", name: "port_uart_cf0_uart_rts", desc: "Connect port uart_rts from port group uart_cf0 to this pad." }
                      { value: "7", name: "port_uart_cf0_uart_rx", desc: "Connect port uart_rx from port group uart_cf0 to this pad." }
                      { value: "8", name: "port_uart_cf0_uart_tx", desc: "Connect port uart_tx from port group uart_cf0 to this pad." }
                      { value: "9", name: "port_uart_cf1_uart_cts", desc: "Connect port uart_cts from port group uart_cf1 to this pad." }
                      { value: "10", name: "port_uart_cf1_uart_rts", desc: "Connect port uart_rts from port group uart_cf1 to this pad." }
                      { value: "11", name: "port_uart_cf1_uart_rx", desc: "Connect port uart_rx from port group uart_cf1 to this pad." }
                      { value: "12", name: "port_uart_cf1_uart_tx", desc: "Connect port uart_tx from port group uart_cf1 to this pad." }
                      { value: "13", name: "port_uart_cf2_uart_cts", desc: "Connect port uart_cts from port group uart_cf2 to this pad." }
                      { value: "14", name: "port_uart_cf2_uart_rts", desc: "Connect port uart_rts from port group uart_cf2 to this pad." }
                      { value: "15", name: "port_uart_cf2_uart_rx", desc: "Connect port uart_rx from port group uart_cf2 to this pad." }
                      { value: "16", name: "port_uart_cf2_uart_tx", desc: "Connect port uart_tx from port group uart_cf2 to this pad." }
                  ]
              }
          ]
      }

      {
          name: PAD_IO_D_06_CFG
          desc: '''
            Pad signal configuration.
          '''
          swaccess: "rw"
          fields: [
            {
                bits: "0"
                name: chip2pad
                desc: '''
                     The signal that connects to the pads TX driver
                '''
                swaccess: "rw"
                hwaccess: "hro"
                resval: "0"
            },
            {
                bits: "1"
                name: oen
                desc: '''
                     Output enable signal, active low
                '''
                swaccess: "rw"
                hwaccess: "hro"
                resval: "1"
            },
          ]
      }

       {
          name: PAD_IO_D_06_MUX_SEL
          desc: '''
              Pad signal port multiplex selection for pad pad_io_d_06. The programmed value defines which port
              is connected to the pad.
          '''
          swaccess: "rw"
          hwaccess: "hro"
          resval: 0
          fields: [
              {
                  bits: "4:0"
                  enum: [
                      { value: "0", name: "register", desc: "Connects the Pad to the internal configuration register."}
                      { value: "1", name: "port_uart0_uart_rx", desc: "Connect port uart_rx from port group uart0 to this pad." }
                      { value: "2", name: "port_uart0_uart_tx", desc: "Connect port uart_tx from port group uart0 to this pad." }
                      { value: "3", name: "port_uart1_uart_rx", desc: "Connect port uart_rx from port group uart1 to this pad." }
                      { value: "4", name: "port_uart1_uart_tx", desc: "Connect port uart_tx from port group uart1 to this pad." }
                      { value: "5", name: "port_uart_cf0_uart_cts", desc: "Connect port uart_cts from port group uart_cf0 to this pad." }
                      { value: "6", name: "port_uart_cf0_uart_rts", desc: "Connect port uart_rts from port group uart_cf0 to this pad." }
                      { value: "7", name: "port_uart_cf0_uart_rx", desc: "Connect port uart_rx from port group uart_cf0 to this pad." }
                      { value: "8", name: "port_uart_cf0_uart_tx", desc: "Connect port uart_tx from port group uart_cf0 to this pad." }
                      { value: "9", name: "port_uart_cf1_uart_cts", desc: "Connect port uart_cts from port group uart_cf1 to this pad." }
                      { value: "10", name: "port_uart_cf1_uart_rts", desc: "Connect port uart_rts from port group uart_cf1 to this pad." }
                      { value: "11", name: "port_uart_cf1_uart_rx", desc: "Connect port uart_rx from port group uart_cf1 to this pad." }
                      { value: "12", name: "port_uart_cf1_uart_tx", desc: "Connect port uart_tx from port group uart_cf1 to this pad." }
                      { value: "13", name: "port_uart_cf2_uart_cts", desc: "Connect port uart_cts from port group uart_cf2 to this pad." }
                      { value: "14", name: "port_uart_cf2_uart_rts", desc: "Connect port uart_rts from port group uart_cf2 to this pad." }
                      { value: "15", name: "port_uart_cf2_uart_rx", desc: "Connect port uart_rx from port group uart_cf2 to this pad." }
                      { value: "16", name: "port_uart_cf2_uart_tx", desc: "Connect port uart_tx from port group uart_cf2 to this pad." }
                  ]
              }
          ]
      }

      {
          name: PAD_IO_D_07_CFG
          desc: '''
            Pad signal configuration.
          '''
          swaccess: "rw"
          fields: [
            {
                bits: "0"
                name: chip2pad
                desc: '''
                     The signal that connects to the pads TX driver
                '''
                swaccess: "rw"
                hwaccess: "hro"
                resval: "0"
            },
            {
                bits: "1"
                name: oen
                desc: '''
                     Output enable signal, active low
                '''
                swaccess: "rw"
                hwaccess: "hro"
                resval: "1"
            },
          ]
      }

       {
          name: PAD_IO_D_07_MUX_SEL
          desc: '''
              Pad signal port multiplex selection for pad pad_io_d_07. The programmed value defines which port
              is connected to the pad.
          '''
          swaccess: "rw"
          hwaccess: "hro"
          resval: 0
          fields: [
              {
                  bits: "4:0"
                  enum: [
                      { value: "0", name: "register", desc: "Connects the Pad to the internal configuration register."}
                      { value: "1", name: "port_uart0_uart_rx", desc: "Connect port uart_rx from port group uart0 to this pad." }
                      { value: "2", name: "port_uart0_uart_tx", desc: "Connect port uart_tx from port group uart0 to this pad." }
                      { value: "3", name: "port_uart1_uart_rx", desc: "Connect port uart_rx from port group uart1 to this pad." }
                      { value: "4", name: "port_uart1_uart_tx", desc: "Connect port uart_tx from port group uart1 to this pad." }
                      { value: "5", name: "port_uart_cf0_uart_cts", desc: "Connect port uart_cts from port group uart_cf0 to this pad." }
                      { value: "6", name: "port_uart_cf0_uart_rts", desc: "Connect port uart_rts from port group uart_cf0 to this pad." }
                      { value: "7", name: "port_uart_cf0_uart_rx", desc: "Connect port uart_rx from port group uart_cf0 to this pad." }
                      { value: "8", name: "port_uart_cf0_uart_tx", desc: "Connect port uart_tx from port group uart_cf0 to this pad." }
                      { value: "9", name: "port_uart_cf1_uart_cts", desc: "Connect port uart_cts from port group uart_cf1 to this pad." }
                      { value: "10", name: "port_uart_cf1_uart_rts", desc: "Connect port uart_rts from port group uart_cf1 to this pad." }
                      { value: "11", name: "port_uart_cf1_uart_rx", desc: "Connect port uart_rx from port group uart_cf1 to this pad." }
                      { value: "12", name: "port_uart_cf1_uart_tx", desc: "Connect port uart_tx from port group uart_cf1 to this pad." }
                      { value: "13", name: "port_uart_cf2_uart_cts", desc: "Connect port uart_cts from port group uart_cf2 to this pad." }
                      { value: "14", name: "port_uart_cf2_uart_rts", desc: "Connect port uart_rts from port group uart_cf2 to this pad." }
                      { value: "15", name: "port_uart_cf2_uart_rx", desc: "Connect port uart_rx from port group uart_cf2 to this pad." }
                      { value: "16", name: "port_uart_cf2_uart_tx", desc: "Connect port uart_tx from port group uart_cf2 to this pad." }
                  ]
              }
          ]
      }

      {
          name: PAD_IO_D_08_CFG
          desc: '''
            Pad signal configuration.
          '''
          swaccess: "rw"
          fields: [
            {
                bits: "0"
                name: chip2pad
                desc: '''
                     The signal that connects to the pads TX driver
                '''
                swaccess: "rw"
                hwaccess: "hro"
                resval: "0"
            },
            {
                bits: "1"
                name: oen
                desc: '''
                     Output enable signal, active low
                '''
                swaccess: "rw"
                hwaccess: "hro"
                resval: "1"
            },
          ]
      }

       {
          name: PAD_IO_D_08_MUX_SEL
          desc: '''
              Pad signal port multiplex selection for pad pad_io_d_08. The programmed value defines which port
              is connected to the pad.
          '''
          swaccess: "rw"
          hwaccess: "hro"
          resval: 0
          fields: [
              {
                  bits: "4:0"
                  enum: [
                      { value: "0", name: "register", desc: "Connects the Pad to the internal configuration register."}
                      { value: "1", name: "port_uart0_uart_rx", desc: "Connect port uart_rx from port group uart0 to this pad." }
                      { value: "2", name: "port_uart0_uart_tx", desc: "Connect port uart_tx from port group uart0 to this pad." }
                      { value: "3", name: "port_uart1_uart_rx", desc: "Connect port uart_rx from port group uart1 to this pad." }
                      { value: "4", name: "port_uart1_uart_tx", desc: "Connect port uart_tx from port group uart1 to this pad." }
                      { value: "5", name: "port_uart_cf0_uart_cts", desc: "Connect port uart_cts from port group uart_cf0 to this pad." }
                      { value: "6", name: "port_uart_cf0_uart_rts", desc: "Connect port uart_rts from port group uart_cf0 to this pad." }
                      { value: "7", name: "port_uart_cf0_uart_rx", desc: "Connect port uart_rx from port group uart_cf0 to this pad." }
                      { value: "8", name: "port_uart_cf0_uart_tx", desc: "Connect port uart_tx from port group uart_cf0 to this pad." }
                      { value: "9", name: "port_uart_cf1_uart_cts", desc: "Connect port uart_cts from port group uart_cf1 to this pad." }
                      { value: "10", name: "port_uart_cf1_uart_rts", desc: "Connect port uart_rts from port group uart_cf1 to this pad." }
                      { value: "11", name: "port_uart_cf1_uart_rx", desc: "Connect port uart_rx from port group uart_cf1 to this pad." }
                      { value: "12", name: "port_uart_cf1_uart_tx", desc: "Connect port uart_tx from port group uart_cf1 to this pad." }
                      { value: "13", name: "port_uart_cf2_uart_cts", desc: "Connect port uart_cts from port group uart_cf2 to this pad." }
                      { value: "14", name: "port_uart_cf2_uart_rts", desc: "Connect port uart_rts from port group uart_cf2 to this pad." }
                      { value: "15", name: "port_uart_cf2_uart_rx", desc: "Connect port uart_rx from port group uart_cf2 to this pad." }
                      { value: "16", name: "port_uart_cf2_uart_tx", desc: "Connect port uart_tx from port group uart_cf2 to this pad." }
                  ]
              }
          ]
      }

      {
          name: PAD_IO_D_09_CFG
          desc: '''
            Pad signal configuration.
          '''
          swaccess: "rw"
          fields: [
            {
                bits: "0"
                name: chip2pad
                desc: '''
                     The signal that connects to the pads TX driver
                '''
                swaccess: "rw"
                hwaccess: "hro"
                resval: "0"
            },
            {
                bits: "1"
                name: oen
                desc: '''
                     Output enable signal, active low
                '''
                swaccess: "rw"
                hwaccess: "hro"
                resval: "1"
            },
          ]
      }

       {
          name: PAD_IO_D_09_MUX_SEL
          desc: '''
              Pad signal port multiplex selection for pad pad_io_d_09. The programmed value defines which port
              is connected to the pad.
          '''
          swaccess: "rw"
          hwaccess: "hro"
          resval: 0
          fields: [
              {
                  bits: "4:0"
                  enum: [
                      { value: "0", name: "register", desc: "Connects the Pad to the internal configuration register."}
                      { value: "1", name: "port_uart0_uart_rx", desc: "Connect port uart_rx from port group uart0 to this pad." }
                      { value: "2", name: "port_uart0_uart_tx", desc: "Connect port uart_tx from port group uart0 to this pad." }
                      { value: "3", name: "port_uart1_uart_rx", desc: "Connect port uart_rx from port group uart1 to this pad." }
                      { value: "4", name: "port_uart1_uart_tx", desc: "Connect port uart_tx from port group uart1 to this pad." }
                      { value: "5", name: "port_uart_cf0_uart_cts", desc: "Connect port uart_cts from port group uart_cf0 to this pad." }
                      { value: "6", name: "port_uart_cf0_uart_rts", desc: "Connect port uart_rts from port group uart_cf0 to this pad." }
                      { value: "7", name: "port_uart_cf0_uart_rx", desc: "Connect port uart_rx from port group uart_cf0 to this pad." }
                      { value: "8", name: "port_uart_cf0_uart_tx", desc: "Connect port uart_tx from port group uart_cf0 to this pad." }
                      { value: "9", name: "port_uart_cf1_uart_cts", desc: "Connect port uart_cts from port group uart_cf1 to this pad." }
                      { value: "10", name: "port_uart_cf1_uart_rts", desc: "Connect port uart_rts from port group uart_cf1 to this pad." }
                      { value: "11", name: "port_uart_cf1_uart_rx", desc: "Connect port uart_rx from port group uart_cf1 to this pad." }
                      { value: "12", name: "port_uart_cf1_uart_tx", desc: "Connect port uart_tx from port group uart_cf1 to this pad." }
                      { value: "13", name: "port_uart_cf2_uart_cts", desc: "Connect port uart_cts from port group uart_cf2 to this pad." }
                      { value: "14", name: "port_uart_cf2_uart_rts", desc: "Connect port uart_rts from port group uart_cf2 to this pad." }
                      { value: "15", name: "port_uart_cf2_uart_rx", desc: "Connect port uart_rx from port group uart_cf2 to this pad." }
                      { value: "16", name: "port_uart_cf2_uart_tx", desc: "Connect port uart_tx from port group uart_cf2 to this pad." }
                  ]
              }
          ]
      }

      {
          name: PAD_IO_D_10_CFG
          desc: '''
            Pad signal configuration.
          '''
          swaccess: "rw"
          fields: [
            {
                bits: "0"
                name: chip2pad
                desc: '''
                     The signal that connects to the pads TX driver
                '''
                swaccess: "rw"
                hwaccess: "hro"
                resval: "0"
            },
            {
                bits: "1"
                name: oen
                desc: '''
                     Output enable signal, active low
                '''
                swaccess: "rw"
                hwaccess: "hro"
                resval: "1"
            },
          ]
      }

       {
          name: PAD_IO_D_10_MUX_SEL
          desc: '''
              Pad signal port multiplex selection for pad pad_io_d_10. The programmed value defines which port
              is connected to the pad.
          '''
          swaccess: "rw"
          hwaccess: "hro"
          resval: 0
          fields: [
              {
                  bits: "4:0"
                  enum: [
                      { value: "0", name: "register", desc: "Connects the Pad to the internal configuration register."}
                      { value: "1", name: "port_uart0_uart_rx", desc: "Connect port uart_rx from port group uart0 to this pad." }
                      { value: "2", name: "port_uart0_uart_tx", desc: "Connect port uart_tx from port group uart0 to this pad." }
                      { value: "3", name: "port_uart1_uart_rx", desc: "Connect port uart_rx from port group uart1 to this pad." }
                      { value: "4", name: "port_uart1_uart_tx", desc: "Connect port uart_tx from port group uart1 to this pad." }
                      { value: "5", name: "port_uart_cf0_uart_cts", desc: "Connect port uart_cts from port group uart_cf0 to this pad." }
                      { value: "6", name: "port_uart_cf0_uart_rts", desc: "Connect port uart_rts from port group uart_cf0 to this pad." }
                      { value: "7", name: "port_uart_cf0_uart_rx", desc: "Connect port uart_rx from port group uart_cf0 to this pad." }
                      { value: "8", name: "port_uart_cf0_uart_tx", desc: "Connect port uart_tx from port group uart_cf0 to this pad." }
                      { value: "9", name: "port_uart_cf1_uart_cts", desc: "Connect port uart_cts from port group uart_cf1 to this pad." }
                      { value: "10", name: "port_uart_cf1_uart_rts", desc: "Connect port uart_rts from port group uart_cf1 to this pad." }
                      { value: "11", name: "port_uart_cf1_uart_rx", desc: "Connect port uart_rx from port group uart_cf1 to this pad." }
                      { value: "12", name: "port_uart_cf1_uart_tx", desc: "Connect port uart_tx from port group uart_cf1 to this pad." }
                      { value: "13", name: "port_uart_cf2_uart_cts", desc: "Connect port uart_cts from port group uart_cf2 to this pad." }
                      { value: "14", name: "port_uart_cf2_uart_rts", desc: "Connect port uart_rts from port group uart_cf2 to this pad." }
                      { value: "15", name: "port_uart_cf2_uart_rx", desc: "Connect port uart_rx from port group uart_cf2 to this pad." }
                      { value: "16", name: "port_uart_cf2_uart_tx", desc: "Connect port uart_tx from port group uart_cf2 to this pad." }
                  ]
              }
          ]
      }

      {
          name: PAD_IO_D_11_CFG
          desc: '''
            Pad signal configuration.
          '''
          swaccess: "rw"
          fields: [
            {
                bits: "0"
                name: chip2pad
                desc: '''
                     The signal that connects to the pads TX driver
                '''
                swaccess: "rw"
                hwaccess: "hro"
                resval: "0"
            },
            {
                bits: "1"
                name: oen
                desc: '''
                     Output enable signal, active low
                '''
                swaccess: "rw"
                hwaccess: "hro"
                resval: "1"
            },
          ]
      }

       {
          name: PAD_IO_D_11_MUX_SEL
          desc: '''
              Pad signal port multiplex selection for pad pad_io_d_11. The programmed value defines which port
              is connected to the pad.
          '''
          swaccess: "rw"
          hwaccess: "hro"
          resval: 0
          fields: [
              {
                  bits: "4:0"
                  enum: [
                      { value: "0", name: "register", desc: "Connects the Pad to the internal configuration register."}
                      { value: "1", name: "port_uart0_uart_rx", desc: "Connect port uart_rx from port group uart0 to this pad." }
                      { value: "2", name: "port_uart0_uart_tx", desc: "Connect port uart_tx from port group uart0 to this pad." }
                      { value: "3", name: "port_uart1_uart_rx", desc: "Connect port uart_rx from port group uart1 to this pad." }
                      { value: "4", name: "port_uart1_uart_tx", desc: "Connect port uart_tx from port group uart1 to this pad." }
                      { value: "5", name: "port_uart_cf0_uart_cts", desc: "Connect port uart_cts from port group uart_cf0 to this pad." }
                      { value: "6", name: "port_uart_cf0_uart_rts", desc: "Connect port uart_rts from port group uart_cf0 to this pad." }
                      { value: "7", name: "port_uart_cf0_uart_rx", desc: "Connect port uart_rx from port group uart_cf0 to this pad." }
                      { value: "8", name: "port_uart_cf0_uart_tx", desc: "Connect port uart_tx from port group uart_cf0 to this pad." }
                      { value: "9", name: "port_uart_cf1_uart_cts", desc: "Connect port uart_cts from port group uart_cf1 to this pad." }
                      { value: "10", name: "port_uart_cf1_uart_rts", desc: "Connect port uart_rts from port group uart_cf1 to this pad." }
                      { value: "11", name: "port_uart_cf1_uart_rx", desc: "Connect port uart_rx from port group uart_cf1 to this pad." }
                      { value: "12", name: "port_uart_cf1_uart_tx", desc: "Connect port uart_tx from port group uart_cf1 to this pad." }
                      { value: "13", name: "port_uart_cf2_uart_cts", desc: "Connect port uart_cts from port group uart_cf2 to this pad." }
                      { value: "14", name: "port_uart_cf2_uart_rts", desc: "Connect port uart_rts from port group uart_cf2 to this pad." }
                      { value: "15", name: "port_uart_cf2_uart_rx", desc: "Connect port uart_rx from port group uart_cf2 to this pad." }
                      { value: "16", name: "port_uart_cf2_uart_tx", desc: "Connect port uart_tx from port group uart_cf2 to this pad." }
                  ]
              }
          ]
      }

      {
          name: PAD_IO_D_12_CFG
          desc: '''
            Pad signal configuration.
          '''
          swaccess: "rw"
          fields: [
            {
                bits: "0"
                name: chip2pad
                desc: '''
                     The signal that connects to the pads TX driver
                '''
                swaccess: "rw"
                hwaccess: "hro"
                resval: "0"
            },
            {
                bits: "1"
                name: oen
                desc: '''
                     Output enable signal, active low
                '''
                swaccess: "rw"
                hwaccess: "hro"
                resval: "1"
            },
          ]
      }

       {
          name: PAD_IO_D_12_MUX_SEL
          desc: '''
              Pad signal port multiplex selection for pad pad_io_d_12. The programmed value defines which port
              is connected to the pad.
          '''
          swaccess: "rw"
          hwaccess: "hro"
          resval: 0
          fields: [
              {
                  bits: "4:0"
                  enum: [
                      { value: "0", name: "register", desc: "Connects the Pad to the internal configuration register."}
                      { value: "1", name: "port_uart0_uart_rx", desc: "Connect port uart_rx from port group uart0 to this pad." }
                      { value: "2", name: "port_uart0_uart_tx", desc: "Connect port uart_tx from port group uart0 to this pad." }
                      { value: "3", name: "port_uart1_uart_rx", desc: "Connect port uart_rx from port group uart1 to this pad." }
                      { value: "4", name: "port_uart1_uart_tx", desc: "Connect port uart_tx from port group uart1 to this pad." }
                      { value: "5", name: "port_uart_cf0_uart_cts", desc: "Connect port uart_cts from port group uart_cf0 to this pad." }
                      { value: "6", name: "port_uart_cf0_uart_rts", desc: "Connect port uart_rts from port group uart_cf0 to this pad." }
                      { value: "7", name: "port_uart_cf0_uart_rx", desc: "Connect port uart_rx from port group uart_cf0 to this pad." }
                      { value: "8", name: "port_uart_cf0_uart_tx", desc: "Connect port uart_tx from port group uart_cf0 to this pad." }
                      { value: "9", name: "port_uart_cf1_uart_cts", desc: "Connect port uart_cts from port group uart_cf1 to this pad." }
                      { value: "10", name: "port_uart_cf1_uart_rts", desc: "Connect port uart_rts from port group uart_cf1 to this pad." }
                      { value: "11", name: "port_uart_cf1_uart_rx", desc: "Connect port uart_rx from port group uart_cf1 to this pad." }
                      { value: "12", name: "port_uart_cf1_uart_tx", desc: "Connect port uart_tx from port group uart_cf1 to this pad." }
                      { value: "13", name: "port_uart_cf2_uart_cts", desc: "Connect port uart_cts from port group uart_cf2 to this pad." }
                      { value: "14", name: "port_uart_cf2_uart_rts", desc: "Connect port uart_rts from port group uart_cf2 to this pad." }
                      { value: "15", name: "port_uart_cf2_uart_rx", desc: "Connect port uart_rx from port group uart_cf2 to this pad." }
                      { value: "16", name: "port_uart_cf2_uart_tx", desc: "Connect port uart_tx from port group uart_cf2 to this pad." }
                  ]
              }
          ]
      }

      {
          name: PAD_IO_D_13_CFG
          desc: '''
            Pad signal configuration.
          '''
          swaccess: "rw"
          fields: [
            {
                bits: "0"
                name: chip2pad
                desc: '''
                     The signal that connects to the pads TX driver
                '''
                swaccess: "rw"
                hwaccess: "hro"
                resval: "0"
            },
            {
                bits: "1"
                name: oen
                desc: '''
                     Output enable signal, active low
                '''
                swaccess: "rw"
                hwaccess: "hro"
                resval: "1"
            },
          ]
      }

       {
          name: PAD_IO_D_13_MUX_SEL
          desc: '''
              Pad signal port multiplex selection for pad pad_io_d_13. The programmed value defines which port
              is connected to the pad.
          '''
          swaccess: "rw"
          hwaccess: "hro"
          resval: 0
          fields: [
              {
                  bits: "4:0"
                  enum: [
                      { value: "0", name: "register", desc: "Connects the Pad to the internal configuration register."}
                      { value: "1", name: "port_uart0_uart_rx", desc: "Connect port uart_rx from port group uart0 to this pad." }
                      { value: "2", name: "port_uart0_uart_tx", desc: "Connect port uart_tx from port group uart0 to this pad." }
                      { value: "3", name: "port_uart1_uart_rx", desc: "Connect port uart_rx from port group uart1 to this pad." }
                      { value: "4", name: "port_uart1_uart_tx", desc: "Connect port uart_tx from port group uart1 to this pad." }
                      { value: "5", name: "port_uart_cf0_uart_cts", desc: "Connect port uart_cts from port group uart_cf0 to this pad." }
                      { value: "6", name: "port_uart_cf0_uart_rts", desc: "Connect port uart_rts from port group uart_cf0 to this pad." }
                      { value: "7", name: "port_uart_cf0_uart_rx", desc: "Connect port uart_rx from port group uart_cf0 to this pad." }
                      { value: "8", name: "port_uart_cf0_uart_tx", desc: "Connect port uart_tx from port group uart_cf0 to this pad." }
                      { value: "9", name: "port_uart_cf1_uart_cts", desc: "Connect port uart_cts from port group uart_cf1 to this pad." }
                      { value: "10", name: "port_uart_cf1_uart_rts", desc: "Connect port uart_rts from port group uart_cf1 to this pad." }
                      { value: "11", name: "port_uart_cf1_uart_rx", desc: "Connect port uart_rx from port group uart_cf1 to this pad." }
                      { value: "12", name: "port_uart_cf1_uart_tx", desc: "Connect port uart_tx from port group uart_cf1 to this pad." }
                      { value: "13", name: "port_uart_cf2_uart_cts", desc: "Connect port uart_cts from port group uart_cf2 to this pad." }
                      { value: "14", name: "port_uart_cf2_uart_rts", desc: "Connect port uart_rts from port group uart_cf2 to this pad." }
                      { value: "15", name: "port_uart_cf2_uart_rx", desc: "Connect port uart_rx from port group uart_cf2 to this pad." }
                      { value: "16", name: "port_uart_cf2_uart_tx", desc: "Connect port uart_tx from port group uart_cf2 to this pad." }
                  ]
              }
          ]
      }

      {
          name: PAD_IO_D_14_CFG
          desc: '''
            Pad signal configuration.
          '''
          swaccess: "rw"
          fields: [
            {
                bits: "0"
                name: chip2pad
                desc: '''
                     The signal that connects to the pads TX driver
                '''
                swaccess: "rw"
                hwaccess: "hro"
                resval: "0"
            },
            {
                bits: "1"
                name: oen
                desc: '''
                     Output enable signal, active low
                '''
                swaccess: "rw"
                hwaccess: "hro"
                resval: "1"
            },
          ]
      }

       {
          name: PAD_IO_D_14_MUX_SEL
          desc: '''
              Pad signal port multiplex selection for pad pad_io_d_14. The programmed value defines which port
              is connected to the pad.
          '''
          swaccess: "rw"
          hwaccess: "hro"
          resval: 0
          fields: [
              {
                  bits: "4:0"
                  enum: [
                      { value: "0", name: "register", desc: "Connects the Pad to the internal configuration register."}
                      { value: "1", name: "port_uart0_uart_rx", desc: "Connect port uart_rx from port group uart0 to this pad." }
                      { value: "2", name: "port_uart0_uart_tx", desc: "Connect port uart_tx from port group uart0 to this pad." }
                      { value: "3", name: "port_uart1_uart_rx", desc: "Connect port uart_rx from port group uart1 to this pad." }
                      { value: "4", name: "port_uart1_uart_tx", desc: "Connect port uart_tx from port group uart1 to this pad." }
                      { value: "5", name: "port_uart_cf0_uart_cts", desc: "Connect port uart_cts from port group uart_cf0 to this pad." }
                      { value: "6", name: "port_uart_cf0_uart_rts", desc: "Connect port uart_rts from port group uart_cf0 to this pad." }
                      { value: "7", name: "port_uart_cf0_uart_rx", desc: "Connect port uart_rx from port group uart_cf0 to this pad." }
                      { value: "8", name: "port_uart_cf0_uart_tx", desc: "Connect port uart_tx from port group uart_cf0 to this pad." }
                      { value: "9", name: "port_uart_cf1_uart_cts", desc: "Connect port uart_cts from port group uart_cf1 to this pad." }
                      { value: "10", name: "port_uart_cf1_uart_rts", desc: "Connect port uart_rts from port group uart_cf1 to this pad." }
                      { value: "11", name: "port_uart_cf1_uart_rx", desc: "Connect port uart_rx from port group uart_cf1 to this pad." }
                      { value: "12", name: "port_uart_cf1_uart_tx", desc: "Connect port uart_tx from port group uart_cf1 to this pad." }
                      { value: "13", name: "port_uart_cf2_uart_cts", desc: "Connect port uart_cts from port group uart_cf2 to this pad." }
                      { value: "14", name: "port_uart_cf2_uart_rts", desc: "Connect port uart_rts from port group uart_cf2 to this pad." }
                      { value: "15", name: "port_uart_cf2_uart_rx", desc: "Connect port uart_rx from port group uart_cf2 to this pad." }
                      { value: "16", name: "port_uart_cf2_uart_tx", desc: "Connect port uart_tx from port group uart_cf2 to this pad." }
                  ]
              }
          ]
      }

      {
          name: PAD_IO_D_15_CFG
          desc: '''
            Pad signal configuration.
          '''
          swaccess: "rw"
          fields: [
            {
                bits: "0"
                name: chip2pad
                desc: '''
                     The signal that connects to the pads TX driver
                '''
                swaccess: "rw"
                hwaccess: "hro"
                resval: "0"
            },
            {
                bits: "1"
                name: oen
                desc: '''
                     Output enable signal, active low
                '''
                swaccess: "rw"
                hwaccess: "hro"
                resval: "1"
            },
          ]
      }

       {
          name: PAD_IO_D_15_MUX_SEL
          desc: '''
              Pad signal port multiplex selection for pad pad_io_d_15. The programmed value defines which port
              is connected to the pad.
          '''
          swaccess: "rw"
          hwaccess: "hro"
          resval: 0
          fields: [
              {
                  bits: "4:0"
                  enum: [
                      { value: "0", name: "register", desc: "Connects the Pad to the internal configuration register."}
                      { value: "1", name: "port_uart0_uart_rx", desc: "Connect port uart_rx from port group uart0 to this pad." }
                      { value: "2", name: "port_uart0_uart_tx", desc: "Connect port uart_tx from port group uart0 to this pad." }
                      { value: "3", name: "port_uart1_uart_rx", desc: "Connect port uart_rx from port group uart1 to this pad." }
                      { value: "4", name: "port_uart1_uart_tx", desc: "Connect port uart_tx from port group uart1 to this pad." }
                      { value: "5", name: "port_uart_cf0_uart_cts", desc: "Connect port uart_cts from port group uart_cf0 to this pad." }
                      { value: "6", name: "port_uart_cf0_uart_rts", desc: "Connect port uart_rts from port group uart_cf0 to this pad." }
                      { value: "7", name: "port_uart_cf0_uart_rx", desc: "Connect port uart_rx from port group uart_cf0 to this pad." }
                      { value: "8", name: "port_uart_cf0_uart_tx", desc: "Connect port uart_tx from port group uart_cf0 to this pad." }
                      { value: "9", name: "port_uart_cf1_uart_cts", desc: "Connect port uart_cts from port group uart_cf1 to this pad." }
                      { value: "10", name: "port_uart_cf1_uart_rts", desc: "Connect port uart_rts from port group uart_cf1 to this pad." }
                      { value: "11", name: "port_uart_cf1_uart_rx", desc: "Connect port uart_rx from port group uart_cf1 to this pad." }
                      { value: "12", name: "port_uart_cf1_uart_tx", desc: "Connect port uart_tx from port group uart_cf1 to this pad." }
                      { value: "13", name: "port_uart_cf2_uart_cts", desc: "Connect port uart_cts from port group uart_cf2 to this pad." }
                      { value: "14", name: "port_uart_cf2_uart_rts", desc: "Connect port uart_rts from port group uart_cf2 to this pad." }
                      { value: "15", name: "port_uart_cf2_uart_rx", desc: "Connect port uart_rx from port group uart_cf2 to this pad." }
                      { value: "16", name: "port_uart_cf2_uart_tx", desc: "Connect port uart_tx from port group uart_cf2 to this pad." }
                  ]
              }
          ]
      }

      {
          name: PAD_IO_E_00_CFG
          desc: '''
            Pad signal configuration.
          '''
          swaccess: "rw"
          fields: [
            {
                bits: "0"
                name: chip2pad
                desc: '''
                     The signal that connects to the pads TX driver
                '''
                swaccess: "rw"
                hwaccess: "hro"
                resval: "0"
            },
            {
                bits: "1"
                name: oen
                desc: '''
                     Output enable signal, active low
                '''
                swaccess: "rw"
                hwaccess: "hro"
                resval: "1"
            },
          ]
      }

       {
          name: PAD_IO_E_00_MUX_SEL
          desc: '''
              Pad signal port multiplex selection for pad pad_io_e_00. The programmed value defines which port
              is connected to the pad.
          '''
          swaccess: "rw"
          hwaccess: "hro"
          resval: 0
          fields: [
              {
                  bits: "4:0"
                  enum: [
                      { value: "0", name: "register", desc: "Connects the Pad to the internal configuration register."}
                      { value: "1", name: "port_CAN2_CAN_can1_rx", desc: "Connect port can1_rx from port group CAN2_CAN to this pad." }
                      { value: "2", name: "port_CAN2_CAN_can1_tx", desc: "Connect port can1_tx from port group CAN2_CAN to this pad." }
                      { value: "3", name: "port_CAN2_CAN_can2_rx", desc: "Connect port can2_rx from port group CAN2_CAN to this pad." }
                      { value: "4", name: "port_CAN2_CAN_can2_tx", desc: "Connect port can2_tx from port group CAN2_CAN to this pad." }
                      { value: "5", name: "port_cam0_cam_data0_i", desc: "Connect port cam_data0_i from port group cam0 to this pad." }
                      { value: "6", name: "port_cam0_cam_data1_i", desc: "Connect port cam_data1_i from port group cam0 to this pad." }
                      { value: "7", name: "port_cam0_cam_data2_i", desc: "Connect port cam_data2_i from port group cam0 to this pad." }
                      { value: "8", name: "port_cam0_cam_data3_i", desc: "Connect port cam_data3_i from port group cam0 to this pad." }
                      { value: "9", name: "port_cam0_cam_data4_i", desc: "Connect port cam_data4_i from port group cam0 to this pad." }
                      { value: "10", name: "port_cam0_cam_data5_i", desc: "Connect port cam_data5_i from port group cam0 to this pad." }
                      { value: "11", name: "port_cam0_cam_data6_i", desc: "Connect port cam_data6_i from port group cam0 to this pad." }
                      { value: "12", name: "port_cam0_cam_data7_i", desc: "Connect port cam_data7_i from port group cam0 to this pad." }
                      { value: "13", name: "port_cam0_cam_hsync", desc: "Connect port cam_hsync from port group cam0 to this pad." }
                      { value: "14", name: "port_cam0_cam_pclk", desc: "Connect port cam_pclk from port group cam0 to this pad." }
                      { value: "15", name: "port_cam0_cam_vsync", desc: "Connect port cam_vsync from port group cam0 to this pad." }
                      { value: "16", name: "port_i2c3_i2c_scl", desc: "Connect port i2c_scl from port group i2c3 to this pad." }
                      { value: "17", name: "port_i2c3_i2c_sda", desc: "Connect port i2c_sda from port group i2c3 to this pad." }
                      { value: "18", name: "port_spi7_spi_cs", desc: "Connect port spi_cs from port group spi7 to this pad." }
                      { value: "19", name: "port_spi7_spi_miso", desc: "Connect port spi_miso from port group spi7 to this pad." }
                      { value: "20", name: "port_spi7_spi_mosi", desc: "Connect port spi_mosi from port group spi7 to this pad." }
                      { value: "21", name: "port_spi7_spi_sck", desc: "Connect port spi_sck from port group spi7 to this pad." }
                      { value: "22", name: "port_spi8_spi_cs", desc: "Connect port spi_cs from port group spi8 to this pad." }
                      { value: "23", name: "port_spi8_spi_miso", desc: "Connect port spi_miso from port group spi8 to this pad." }
                      { value: "24", name: "port_spi8_spi_mosi", desc: "Connect port spi_mosi from port group spi8 to this pad." }
                      { value: "25", name: "port_spi8_spi_sck", desc: "Connect port spi_sck from port group spi8 to this pad." }
                      { value: "26", name: "port_spi9_spi_cs", desc: "Connect port spi_cs from port group spi9 to this pad." }
                      { value: "27", name: "port_spi9_spi_miso", desc: "Connect port spi_miso from port group spi9 to this pad." }
                      { value: "28", name: "port_spi9_spi_mosi", desc: "Connect port spi_mosi from port group spi9 to this pad." }
                      { value: "29", name: "port_spi9_spi_sck", desc: "Connect port spi_sck from port group spi9 to this pad." }
                  ]
              }
          ]
      }

      {
          name: PAD_IO_E_01_CFG
          desc: '''
            Pad signal configuration.
          '''
          swaccess: "rw"
          fields: [
            {
                bits: "0"
                name: chip2pad
                desc: '''
                     The signal that connects to the pads TX driver
                '''
                swaccess: "rw"
                hwaccess: "hro"
                resval: "0"
            },
            {
                bits: "1"
                name: oen
                desc: '''
                     Output enable signal, active low
                '''
                swaccess: "rw"
                hwaccess: "hro"
                resval: "1"
            },
          ]
      }

       {
          name: PAD_IO_E_01_MUX_SEL
          desc: '''
              Pad signal port multiplex selection for pad pad_io_e_01. The programmed value defines which port
              is connected to the pad.
          '''
          swaccess: "rw"
          hwaccess: "hro"
          resval: 0
          fields: [
              {
                  bits: "4:0"
                  enum: [
                      { value: "0", name: "register", desc: "Connects the Pad to the internal configuration register."}
                      { value: "1", name: "port_CAN2_CAN_can1_rx", desc: "Connect port can1_rx from port group CAN2_CAN to this pad." }
                      { value: "2", name: "port_CAN2_CAN_can1_tx", desc: "Connect port can1_tx from port group CAN2_CAN to this pad." }
                      { value: "3", name: "port_CAN2_CAN_can2_rx", desc: "Connect port can2_rx from port group CAN2_CAN to this pad." }
                      { value: "4", name: "port_CAN2_CAN_can2_tx", desc: "Connect port can2_tx from port group CAN2_CAN to this pad." }
                      { value: "5", name: "port_cam0_cam_data0_i", desc: "Connect port cam_data0_i from port group cam0 to this pad." }
                      { value: "6", name: "port_cam0_cam_data1_i", desc: "Connect port cam_data1_i from port group cam0 to this pad." }
                      { value: "7", name: "port_cam0_cam_data2_i", desc: "Connect port cam_data2_i from port group cam0 to this pad." }
                      { value: "8", name: "port_cam0_cam_data3_i", desc: "Connect port cam_data3_i from port group cam0 to this pad." }
                      { value: "9", name: "port_cam0_cam_data4_i", desc: "Connect port cam_data4_i from port group cam0 to this pad." }
                      { value: "10", name: "port_cam0_cam_data5_i", desc: "Connect port cam_data5_i from port group cam0 to this pad." }
                      { value: "11", name: "port_cam0_cam_data6_i", desc: "Connect port cam_data6_i from port group cam0 to this pad." }
                      { value: "12", name: "port_cam0_cam_data7_i", desc: "Connect port cam_data7_i from port group cam0 to this pad." }
                      { value: "13", name: "port_cam0_cam_hsync", desc: "Connect port cam_hsync from port group cam0 to this pad." }
                      { value: "14", name: "port_cam0_cam_pclk", desc: "Connect port cam_pclk from port group cam0 to this pad." }
                      { value: "15", name: "port_cam0_cam_vsync", desc: "Connect port cam_vsync from port group cam0 to this pad." }
                      { value: "16", name: "port_i2c3_i2c_scl", desc: "Connect port i2c_scl from port group i2c3 to this pad." }
                      { value: "17", name: "port_i2c3_i2c_sda", desc: "Connect port i2c_sda from port group i2c3 to this pad." }
                      { value: "18", name: "port_spi7_spi_cs", desc: "Connect port spi_cs from port group spi7 to this pad." }
                      { value: "19", name: "port_spi7_spi_miso", desc: "Connect port spi_miso from port group spi7 to this pad." }
                      { value: "20", name: "port_spi7_spi_mosi", desc: "Connect port spi_mosi from port group spi7 to this pad." }
                      { value: "21", name: "port_spi7_spi_sck", desc: "Connect port spi_sck from port group spi7 to this pad." }
                      { value: "22", name: "port_spi8_spi_cs", desc: "Connect port spi_cs from port group spi8 to this pad." }
                      { value: "23", name: "port_spi8_spi_miso", desc: "Connect port spi_miso from port group spi8 to this pad." }
                      { value: "24", name: "port_spi8_spi_mosi", desc: "Connect port spi_mosi from port group spi8 to this pad." }
                      { value: "25", name: "port_spi8_spi_sck", desc: "Connect port spi_sck from port group spi8 to this pad." }
                      { value: "26", name: "port_spi9_spi_cs", desc: "Connect port spi_cs from port group spi9 to this pad." }
                      { value: "27", name: "port_spi9_spi_miso", desc: "Connect port spi_miso from port group spi9 to this pad." }
                      { value: "28", name: "port_spi9_spi_mosi", desc: "Connect port spi_mosi from port group spi9 to this pad." }
                      { value: "29", name: "port_spi9_spi_sck", desc: "Connect port spi_sck from port group spi9 to this pad." }
                  ]
              }
          ]
      }

      {
          name: PAD_IO_E_02_CFG
          desc: '''
            Pad signal configuration.
          '''
          swaccess: "rw"
          fields: [
            {
                bits: "0"
                name: chip2pad
                desc: '''
                     The signal that connects to the pads TX driver
                '''
                swaccess: "rw"
                hwaccess: "hro"
                resval: "0"
            },
            {
                bits: "1"
                name: oen
                desc: '''
                     Output enable signal, active low
                '''
                swaccess: "rw"
                hwaccess: "hro"
                resval: "1"
            },
          ]
      }

       {
          name: PAD_IO_E_02_MUX_SEL
          desc: '''
              Pad signal port multiplex selection for pad pad_io_e_02. The programmed value defines which port
              is connected to the pad.
          '''
          swaccess: "rw"
          hwaccess: "hro"
          resval: 0
          fields: [
              {
                  bits: "4:0"
                  enum: [
                      { value: "0", name: "register", desc: "Connects the Pad to the internal configuration register."}
                      { value: "1", name: "port_CAN2_CAN_can1_rx", desc: "Connect port can1_rx from port group CAN2_CAN to this pad." }
                      { value: "2", name: "port_CAN2_CAN_can1_tx", desc: "Connect port can1_tx from port group CAN2_CAN to this pad." }
                      { value: "3", name: "port_CAN2_CAN_can2_rx", desc: "Connect port can2_rx from port group CAN2_CAN to this pad." }
                      { value: "4", name: "port_CAN2_CAN_can2_tx", desc: "Connect port can2_tx from port group CAN2_CAN to this pad." }
                      { value: "5", name: "port_cam0_cam_data0_i", desc: "Connect port cam_data0_i from port group cam0 to this pad." }
                      { value: "6", name: "port_cam0_cam_data1_i", desc: "Connect port cam_data1_i from port group cam0 to this pad." }
                      { value: "7", name: "port_cam0_cam_data2_i", desc: "Connect port cam_data2_i from port group cam0 to this pad." }
                      { value: "8", name: "port_cam0_cam_data3_i", desc: "Connect port cam_data3_i from port group cam0 to this pad." }
                      { value: "9", name: "port_cam0_cam_data4_i", desc: "Connect port cam_data4_i from port group cam0 to this pad." }
                      { value: "10", name: "port_cam0_cam_data5_i", desc: "Connect port cam_data5_i from port group cam0 to this pad." }
                      { value: "11", name: "port_cam0_cam_data6_i", desc: "Connect port cam_data6_i from port group cam0 to this pad." }
                      { value: "12", name: "port_cam0_cam_data7_i", desc: "Connect port cam_data7_i from port group cam0 to this pad." }
                      { value: "13", name: "port_cam0_cam_hsync", desc: "Connect port cam_hsync from port group cam0 to this pad." }
                      { value: "14", name: "port_cam0_cam_pclk", desc: "Connect port cam_pclk from port group cam0 to this pad." }
                      { value: "15", name: "port_cam0_cam_vsync", desc: "Connect port cam_vsync from port group cam0 to this pad." }
                      { value: "16", name: "port_i2c3_i2c_scl", desc: "Connect port i2c_scl from port group i2c3 to this pad." }
                      { value: "17", name: "port_i2c3_i2c_sda", desc: "Connect port i2c_sda from port group i2c3 to this pad." }
                      { value: "18", name: "port_spi7_spi_cs", desc: "Connect port spi_cs from port group spi7 to this pad." }
                      { value: "19", name: "port_spi7_spi_miso", desc: "Connect port spi_miso from port group spi7 to this pad." }
                      { value: "20", name: "port_spi7_spi_mosi", desc: "Connect port spi_mosi from port group spi7 to this pad." }
                      { value: "21", name: "port_spi7_spi_sck", desc: "Connect port spi_sck from port group spi7 to this pad." }
                      { value: "22", name: "port_spi8_spi_cs", desc: "Connect port spi_cs from port group spi8 to this pad." }
                      { value: "23", name: "port_spi8_spi_miso", desc: "Connect port spi_miso from port group spi8 to this pad." }
                      { value: "24", name: "port_spi8_spi_mosi", desc: "Connect port spi_mosi from port group spi8 to this pad." }
                      { value: "25", name: "port_spi8_spi_sck", desc: "Connect port spi_sck from port group spi8 to this pad." }
                      { value: "26", name: "port_spi9_spi_cs", desc: "Connect port spi_cs from port group spi9 to this pad." }
                      { value: "27", name: "port_spi9_spi_miso", desc: "Connect port spi_miso from port group spi9 to this pad." }
                      { value: "28", name: "port_spi9_spi_mosi", desc: "Connect port spi_mosi from port group spi9 to this pad." }
                      { value: "29", name: "port_spi9_spi_sck", desc: "Connect port spi_sck from port group spi9 to this pad." }
                  ]
              }
          ]
      }

      {
          name: PAD_IO_E_03_CFG
          desc: '''
            Pad signal configuration.
          '''
          swaccess: "rw"
          fields: [
            {
                bits: "0"
                name: chip2pad
                desc: '''
                     The signal that connects to the pads TX driver
                '''
                swaccess: "rw"
                hwaccess: "hro"
                resval: "0"
            },
            {
                bits: "1"
                name: oen
                desc: '''
                     Output enable signal, active low
                '''
                swaccess: "rw"
                hwaccess: "hro"
                resval: "1"
            },
          ]
      }

       {
          name: PAD_IO_E_03_MUX_SEL
          desc: '''
              Pad signal port multiplex selection for pad pad_io_e_03. The programmed value defines which port
              is connected to the pad.
          '''
          swaccess: "rw"
          hwaccess: "hro"
          resval: 0
          fields: [
              {
                  bits: "4:0"
                  enum: [
                      { value: "0", name: "register", desc: "Connects the Pad to the internal configuration register."}
                      { value: "1", name: "port_CAN2_CAN_can1_rx", desc: "Connect port can1_rx from port group CAN2_CAN to this pad." }
                      { value: "2", name: "port_CAN2_CAN_can1_tx", desc: "Connect port can1_tx from port group CAN2_CAN to this pad." }
                      { value: "3", name: "port_CAN2_CAN_can2_rx", desc: "Connect port can2_rx from port group CAN2_CAN to this pad." }
                      { value: "4", name: "port_CAN2_CAN_can2_tx", desc: "Connect port can2_tx from port group CAN2_CAN to this pad." }
                      { value: "5", name: "port_cam0_cam_data0_i", desc: "Connect port cam_data0_i from port group cam0 to this pad." }
                      { value: "6", name: "port_cam0_cam_data1_i", desc: "Connect port cam_data1_i from port group cam0 to this pad." }
                      { value: "7", name: "port_cam0_cam_data2_i", desc: "Connect port cam_data2_i from port group cam0 to this pad." }
                      { value: "8", name: "port_cam0_cam_data3_i", desc: "Connect port cam_data3_i from port group cam0 to this pad." }
                      { value: "9", name: "port_cam0_cam_data4_i", desc: "Connect port cam_data4_i from port group cam0 to this pad." }
                      { value: "10", name: "port_cam0_cam_data5_i", desc: "Connect port cam_data5_i from port group cam0 to this pad." }
                      { value: "11", name: "port_cam0_cam_data6_i", desc: "Connect port cam_data6_i from port group cam0 to this pad." }
                      { value: "12", name: "port_cam0_cam_data7_i", desc: "Connect port cam_data7_i from port group cam0 to this pad." }
                      { value: "13", name: "port_cam0_cam_hsync", desc: "Connect port cam_hsync from port group cam0 to this pad." }
                      { value: "14", name: "port_cam0_cam_pclk", desc: "Connect port cam_pclk from port group cam0 to this pad." }
                      { value: "15", name: "port_cam0_cam_vsync", desc: "Connect port cam_vsync from port group cam0 to this pad." }
                      { value: "16", name: "port_i2c3_i2c_scl", desc: "Connect port i2c_scl from port group i2c3 to this pad." }
                      { value: "17", name: "port_i2c3_i2c_sda", desc: "Connect port i2c_sda from port group i2c3 to this pad." }
                      { value: "18", name: "port_spi7_spi_cs", desc: "Connect port spi_cs from port group spi7 to this pad." }
                      { value: "19", name: "port_spi7_spi_miso", desc: "Connect port spi_miso from port group spi7 to this pad." }
                      { value: "20", name: "port_spi7_spi_mosi", desc: "Connect port spi_mosi from port group spi7 to this pad." }
                      { value: "21", name: "port_spi7_spi_sck", desc: "Connect port spi_sck from port group spi7 to this pad." }
                      { value: "22", name: "port_spi8_spi_cs", desc: "Connect port spi_cs from port group spi8 to this pad." }
                      { value: "23", name: "port_spi8_spi_miso", desc: "Connect port spi_miso from port group spi8 to this pad." }
                      { value: "24", name: "port_spi8_spi_mosi", desc: "Connect port spi_mosi from port group spi8 to this pad." }
                      { value: "25", name: "port_spi8_spi_sck", desc: "Connect port spi_sck from port group spi8 to this pad." }
                      { value: "26", name: "port_spi9_spi_cs", desc: "Connect port spi_cs from port group spi9 to this pad." }
                      { value: "27", name: "port_spi9_spi_miso", desc: "Connect port spi_miso from port group spi9 to this pad." }
                      { value: "28", name: "port_spi9_spi_mosi", desc: "Connect port spi_mosi from port group spi9 to this pad." }
                      { value: "29", name: "port_spi9_spi_sck", desc: "Connect port spi_sck from port group spi9 to this pad." }
                  ]
              }
          ]
      }

      {
          name: PAD_IO_E_04_CFG
          desc: '''
            Pad signal configuration.
          '''
          swaccess: "rw"
          fields: [
            {
                bits: "0"
                name: chip2pad
                desc: '''
                     The signal that connects to the pads TX driver
                '''
                swaccess: "rw"
                hwaccess: "hro"
                resval: "0"
            },
            {
                bits: "1"
                name: oen
                desc: '''
                     Output enable signal, active low
                '''
                swaccess: "rw"
                hwaccess: "hro"
                resval: "1"
            },
          ]
      }

       {
          name: PAD_IO_E_04_MUX_SEL
          desc: '''
              Pad signal port multiplex selection for pad pad_io_e_04. The programmed value defines which port
              is connected to the pad.
          '''
          swaccess: "rw"
          hwaccess: "hro"
          resval: 0
          fields: [
              {
                  bits: "4:0"
                  enum: [
                      { value: "0", name: "register", desc: "Connects the Pad to the internal configuration register."}
                      { value: "1", name: "port_CAN2_CAN_can1_rx", desc: "Connect port can1_rx from port group CAN2_CAN to this pad." }
                      { value: "2", name: "port_CAN2_CAN_can1_tx", desc: "Connect port can1_tx from port group CAN2_CAN to this pad." }
                      { value: "3", name: "port_CAN2_CAN_can2_rx", desc: "Connect port can2_rx from port group CAN2_CAN to this pad." }
                      { value: "4", name: "port_CAN2_CAN_can2_tx", desc: "Connect port can2_tx from port group CAN2_CAN to this pad." }
                      { value: "5", name: "port_cam0_cam_data0_i", desc: "Connect port cam_data0_i from port group cam0 to this pad." }
                      { value: "6", name: "port_cam0_cam_data1_i", desc: "Connect port cam_data1_i from port group cam0 to this pad." }
                      { value: "7", name: "port_cam0_cam_data2_i", desc: "Connect port cam_data2_i from port group cam0 to this pad." }
                      { value: "8", name: "port_cam0_cam_data3_i", desc: "Connect port cam_data3_i from port group cam0 to this pad." }
                      { value: "9", name: "port_cam0_cam_data4_i", desc: "Connect port cam_data4_i from port group cam0 to this pad." }
                      { value: "10", name: "port_cam0_cam_data5_i", desc: "Connect port cam_data5_i from port group cam0 to this pad." }
                      { value: "11", name: "port_cam0_cam_data6_i", desc: "Connect port cam_data6_i from port group cam0 to this pad." }
                      { value: "12", name: "port_cam0_cam_data7_i", desc: "Connect port cam_data7_i from port group cam0 to this pad." }
                      { value: "13", name: "port_cam0_cam_hsync", desc: "Connect port cam_hsync from port group cam0 to this pad." }
                      { value: "14", name: "port_cam0_cam_pclk", desc: "Connect port cam_pclk from port group cam0 to this pad." }
                      { value: "15", name: "port_cam0_cam_vsync", desc: "Connect port cam_vsync from port group cam0 to this pad." }
                      { value: "16", name: "port_i2c3_i2c_scl", desc: "Connect port i2c_scl from port group i2c3 to this pad." }
                      { value: "17", name: "port_i2c3_i2c_sda", desc: "Connect port i2c_sda from port group i2c3 to this pad." }
                      { value: "18", name: "port_spi7_spi_cs", desc: "Connect port spi_cs from port group spi7 to this pad." }
                      { value: "19", name: "port_spi7_spi_miso", desc: "Connect port spi_miso from port group spi7 to this pad." }
                      { value: "20", name: "port_spi7_spi_mosi", desc: "Connect port spi_mosi from port group spi7 to this pad." }
                      { value: "21", name: "port_spi7_spi_sck", desc: "Connect port spi_sck from port group spi7 to this pad." }
                      { value: "22", name: "port_spi8_spi_cs", desc: "Connect port spi_cs from port group spi8 to this pad." }
                      { value: "23", name: "port_spi8_spi_miso", desc: "Connect port spi_miso from port group spi8 to this pad." }
                      { value: "24", name: "port_spi8_spi_mosi", desc: "Connect port spi_mosi from port group spi8 to this pad." }
                      { value: "25", name: "port_spi8_spi_sck", desc: "Connect port spi_sck from port group spi8 to this pad." }
                      { value: "26", name: "port_spi9_spi_cs", desc: "Connect port spi_cs from port group spi9 to this pad." }
                      { value: "27", name: "port_spi9_spi_miso", desc: "Connect port spi_miso from port group spi9 to this pad." }
                      { value: "28", name: "port_spi9_spi_mosi", desc: "Connect port spi_mosi from port group spi9 to this pad." }
                      { value: "29", name: "port_spi9_spi_sck", desc: "Connect port spi_sck from port group spi9 to this pad." }
                  ]
              }
          ]
      }

      {
          name: PAD_IO_E_05_CFG
          desc: '''
            Pad signal configuration.
          '''
          swaccess: "rw"
          fields: [
            {
                bits: "0"
                name: chip2pad
                desc: '''
                     The signal that connects to the pads TX driver
                '''
                swaccess: "rw"
                hwaccess: "hro"
                resval: "0"
            },
            {
                bits: "1"
                name: oen
                desc: '''
                     Output enable signal, active low
                '''
                swaccess: "rw"
                hwaccess: "hro"
                resval: "1"
            },
          ]
      }

       {
          name: PAD_IO_E_05_MUX_SEL
          desc: '''
              Pad signal port multiplex selection for pad pad_io_e_05. The programmed value defines which port
              is connected to the pad.
          '''
          swaccess: "rw"
          hwaccess: "hro"
          resval: 0
          fields: [
              {
                  bits: "4:0"
                  enum: [
                      { value: "0", name: "register", desc: "Connects the Pad to the internal configuration register."}
                      { value: "1", name: "port_CAN2_CAN_can1_rx", desc: "Connect port can1_rx from port group CAN2_CAN to this pad." }
                      { value: "2", name: "port_CAN2_CAN_can1_tx", desc: "Connect port can1_tx from port group CAN2_CAN to this pad." }
                      { value: "3", name: "port_CAN2_CAN_can2_rx", desc: "Connect port can2_rx from port group CAN2_CAN to this pad." }
                      { value: "4", name: "port_CAN2_CAN_can2_tx", desc: "Connect port can2_tx from port group CAN2_CAN to this pad." }
                      { value: "5", name: "port_cam0_cam_data0_i", desc: "Connect port cam_data0_i from port group cam0 to this pad." }
                      { value: "6", name: "port_cam0_cam_data1_i", desc: "Connect port cam_data1_i from port group cam0 to this pad." }
                      { value: "7", name: "port_cam0_cam_data2_i", desc: "Connect port cam_data2_i from port group cam0 to this pad." }
                      { value: "8", name: "port_cam0_cam_data3_i", desc: "Connect port cam_data3_i from port group cam0 to this pad." }
                      { value: "9", name: "port_cam0_cam_data4_i", desc: "Connect port cam_data4_i from port group cam0 to this pad." }
                      { value: "10", name: "port_cam0_cam_data5_i", desc: "Connect port cam_data5_i from port group cam0 to this pad." }
                      { value: "11", name: "port_cam0_cam_data6_i", desc: "Connect port cam_data6_i from port group cam0 to this pad." }
                      { value: "12", name: "port_cam0_cam_data7_i", desc: "Connect port cam_data7_i from port group cam0 to this pad." }
                      { value: "13", name: "port_cam0_cam_hsync", desc: "Connect port cam_hsync from port group cam0 to this pad." }
                      { value: "14", name: "port_cam0_cam_pclk", desc: "Connect port cam_pclk from port group cam0 to this pad." }
                      { value: "15", name: "port_cam0_cam_vsync", desc: "Connect port cam_vsync from port group cam0 to this pad." }
                      { value: "16", name: "port_i2c3_i2c_scl", desc: "Connect port i2c_scl from port group i2c3 to this pad." }
                      { value: "17", name: "port_i2c3_i2c_sda", desc: "Connect port i2c_sda from port group i2c3 to this pad." }
                      { value: "18", name: "port_spi7_spi_cs", desc: "Connect port spi_cs from port group spi7 to this pad." }
                      { value: "19", name: "port_spi7_spi_miso", desc: "Connect port spi_miso from port group spi7 to this pad." }
                      { value: "20", name: "port_spi7_spi_mosi", desc: "Connect port spi_mosi from port group spi7 to this pad." }
                      { value: "21", name: "port_spi7_spi_sck", desc: "Connect port spi_sck from port group spi7 to this pad." }
                      { value: "22", name: "port_spi8_spi_cs", desc: "Connect port spi_cs from port group spi8 to this pad." }
                      { value: "23", name: "port_spi8_spi_miso", desc: "Connect port spi_miso from port group spi8 to this pad." }
                      { value: "24", name: "port_spi8_spi_mosi", desc: "Connect port spi_mosi from port group spi8 to this pad." }
                      { value: "25", name: "port_spi8_spi_sck", desc: "Connect port spi_sck from port group spi8 to this pad." }
                      { value: "26", name: "port_spi9_spi_cs", desc: "Connect port spi_cs from port group spi9 to this pad." }
                      { value: "27", name: "port_spi9_spi_miso", desc: "Connect port spi_miso from port group spi9 to this pad." }
                      { value: "28", name: "port_spi9_spi_mosi", desc: "Connect port spi_mosi from port group spi9 to this pad." }
                      { value: "29", name: "port_spi9_spi_sck", desc: "Connect port spi_sck from port group spi9 to this pad." }
                  ]
              }
          ]
      }

      {
          name: PAD_IO_E_06_CFG
          desc: '''
            Pad signal configuration.
          '''
          swaccess: "rw"
          fields: [
            {
                bits: "0"
                name: chip2pad
                desc: '''
                     The signal that connects to the pads TX driver
                '''
                swaccess: "rw"
                hwaccess: "hro"
                resval: "0"
            },
            {
                bits: "1"
                name: oen
                desc: '''
                     Output enable signal, active low
                '''
                swaccess: "rw"
                hwaccess: "hro"
                resval: "1"
            },
          ]
      }

       {
          name: PAD_IO_E_06_MUX_SEL
          desc: '''
              Pad signal port multiplex selection for pad pad_io_e_06. The programmed value defines which port
              is connected to the pad.
          '''
          swaccess: "rw"
          hwaccess: "hro"
          resval: 0
          fields: [
              {
                  bits: "4:0"
                  enum: [
                      { value: "0", name: "register", desc: "Connects the Pad to the internal configuration register."}
                      { value: "1", name: "port_CAN2_CAN_can1_rx", desc: "Connect port can1_rx from port group CAN2_CAN to this pad." }
                      { value: "2", name: "port_CAN2_CAN_can1_tx", desc: "Connect port can1_tx from port group CAN2_CAN to this pad." }
                      { value: "3", name: "port_CAN2_CAN_can2_rx", desc: "Connect port can2_rx from port group CAN2_CAN to this pad." }
                      { value: "4", name: "port_CAN2_CAN_can2_tx", desc: "Connect port can2_tx from port group CAN2_CAN to this pad." }
                      { value: "5", name: "port_cam0_cam_data0_i", desc: "Connect port cam_data0_i from port group cam0 to this pad." }
                      { value: "6", name: "port_cam0_cam_data1_i", desc: "Connect port cam_data1_i from port group cam0 to this pad." }
                      { value: "7", name: "port_cam0_cam_data2_i", desc: "Connect port cam_data2_i from port group cam0 to this pad." }
                      { value: "8", name: "port_cam0_cam_data3_i", desc: "Connect port cam_data3_i from port group cam0 to this pad." }
                      { value: "9", name: "port_cam0_cam_data4_i", desc: "Connect port cam_data4_i from port group cam0 to this pad." }
                      { value: "10", name: "port_cam0_cam_data5_i", desc: "Connect port cam_data5_i from port group cam0 to this pad." }
                      { value: "11", name: "port_cam0_cam_data6_i", desc: "Connect port cam_data6_i from port group cam0 to this pad." }
                      { value: "12", name: "port_cam0_cam_data7_i", desc: "Connect port cam_data7_i from port group cam0 to this pad." }
                      { value: "13", name: "port_cam0_cam_hsync", desc: "Connect port cam_hsync from port group cam0 to this pad." }
                      { value: "14", name: "port_cam0_cam_pclk", desc: "Connect port cam_pclk from port group cam0 to this pad." }
                      { value: "15", name: "port_cam0_cam_vsync", desc: "Connect port cam_vsync from port group cam0 to this pad." }
                      { value: "16", name: "port_i2c3_i2c_scl", desc: "Connect port i2c_scl from port group i2c3 to this pad." }
                      { value: "17", name: "port_i2c3_i2c_sda", desc: "Connect port i2c_sda from port group i2c3 to this pad." }
                      { value: "18", name: "port_spi7_spi_cs", desc: "Connect port spi_cs from port group spi7 to this pad." }
                      { value: "19", name: "port_spi7_spi_miso", desc: "Connect port spi_miso from port group spi7 to this pad." }
                      { value: "20", name: "port_spi7_spi_mosi", desc: "Connect port spi_mosi from port group spi7 to this pad." }
                      { value: "21", name: "port_spi7_spi_sck", desc: "Connect port spi_sck from port group spi7 to this pad." }
                      { value: "22", name: "port_spi8_spi_cs", desc: "Connect port spi_cs from port group spi8 to this pad." }
                      { value: "23", name: "port_spi8_spi_miso", desc: "Connect port spi_miso from port group spi8 to this pad." }
                      { value: "24", name: "port_spi8_spi_mosi", desc: "Connect port spi_mosi from port group spi8 to this pad." }
                      { value: "25", name: "port_spi8_spi_sck", desc: "Connect port spi_sck from port group spi8 to this pad." }
                      { value: "26", name: "port_spi9_spi_cs", desc: "Connect port spi_cs from port group spi9 to this pad." }
                      { value: "27", name: "port_spi9_spi_miso", desc: "Connect port spi_miso from port group spi9 to this pad." }
                      { value: "28", name: "port_spi9_spi_mosi", desc: "Connect port spi_mosi from port group spi9 to this pad." }
                      { value: "29", name: "port_spi9_spi_sck", desc: "Connect port spi_sck from port group spi9 to this pad." }
                  ]
              }
          ]
      }

      {
          name: PAD_IO_E_07_CFG
          desc: '''
            Pad signal configuration.
          '''
          swaccess: "rw"
          fields: [
            {
                bits: "0"
                name: chip2pad
                desc: '''
                     The signal that connects to the pads TX driver
                '''
                swaccess: "rw"
                hwaccess: "hro"
                resval: "0"
            },
            {
                bits: "1"
                name: oen
                desc: '''
                     Output enable signal, active low
                '''
                swaccess: "rw"
                hwaccess: "hro"
                resval: "1"
            },
          ]
      }

       {
          name: PAD_IO_E_07_MUX_SEL
          desc: '''
              Pad signal port multiplex selection for pad pad_io_e_07. The programmed value defines which port
              is connected to the pad.
          '''
          swaccess: "rw"
          hwaccess: "hro"
          resval: 0
          fields: [
              {
                  bits: "4:0"
                  enum: [
                      { value: "0", name: "register", desc: "Connects the Pad to the internal configuration register."}
                      { value: "1", name: "port_CAN2_CAN_can1_rx", desc: "Connect port can1_rx from port group CAN2_CAN to this pad." }
                      { value: "2", name: "port_CAN2_CAN_can1_tx", desc: "Connect port can1_tx from port group CAN2_CAN to this pad." }
                      { value: "3", name: "port_CAN2_CAN_can2_rx", desc: "Connect port can2_rx from port group CAN2_CAN to this pad." }
                      { value: "4", name: "port_CAN2_CAN_can2_tx", desc: "Connect port can2_tx from port group CAN2_CAN to this pad." }
                      { value: "5", name: "port_cam0_cam_data0_i", desc: "Connect port cam_data0_i from port group cam0 to this pad." }
                      { value: "6", name: "port_cam0_cam_data1_i", desc: "Connect port cam_data1_i from port group cam0 to this pad." }
                      { value: "7", name: "port_cam0_cam_data2_i", desc: "Connect port cam_data2_i from port group cam0 to this pad." }
                      { value: "8", name: "port_cam0_cam_data3_i", desc: "Connect port cam_data3_i from port group cam0 to this pad." }
                      { value: "9", name: "port_cam0_cam_data4_i", desc: "Connect port cam_data4_i from port group cam0 to this pad." }
                      { value: "10", name: "port_cam0_cam_data5_i", desc: "Connect port cam_data5_i from port group cam0 to this pad." }
                      { value: "11", name: "port_cam0_cam_data6_i", desc: "Connect port cam_data6_i from port group cam0 to this pad." }
                      { value: "12", name: "port_cam0_cam_data7_i", desc: "Connect port cam_data7_i from port group cam0 to this pad." }
                      { value: "13", name: "port_cam0_cam_hsync", desc: "Connect port cam_hsync from port group cam0 to this pad." }
                      { value: "14", name: "port_cam0_cam_pclk", desc: "Connect port cam_pclk from port group cam0 to this pad." }
                      { value: "15", name: "port_cam0_cam_vsync", desc: "Connect port cam_vsync from port group cam0 to this pad." }
                      { value: "16", name: "port_i2c3_i2c_scl", desc: "Connect port i2c_scl from port group i2c3 to this pad." }
                      { value: "17", name: "port_i2c3_i2c_sda", desc: "Connect port i2c_sda from port group i2c3 to this pad." }
                      { value: "18", name: "port_spi7_spi_cs", desc: "Connect port spi_cs from port group spi7 to this pad." }
                      { value: "19", name: "port_spi7_spi_miso", desc: "Connect port spi_miso from port group spi7 to this pad." }
                      { value: "20", name: "port_spi7_spi_mosi", desc: "Connect port spi_mosi from port group spi7 to this pad." }
                      { value: "21", name: "port_spi7_spi_sck", desc: "Connect port spi_sck from port group spi7 to this pad." }
                      { value: "22", name: "port_spi8_spi_cs", desc: "Connect port spi_cs from port group spi8 to this pad." }
                      { value: "23", name: "port_spi8_spi_miso", desc: "Connect port spi_miso from port group spi8 to this pad." }
                      { value: "24", name: "port_spi8_spi_mosi", desc: "Connect port spi_mosi from port group spi8 to this pad." }
                      { value: "25", name: "port_spi8_spi_sck", desc: "Connect port spi_sck from port group spi8 to this pad." }
                      { value: "26", name: "port_spi9_spi_cs", desc: "Connect port spi_cs from port group spi9 to this pad." }
                      { value: "27", name: "port_spi9_spi_miso", desc: "Connect port spi_miso from port group spi9 to this pad." }
                      { value: "28", name: "port_spi9_spi_mosi", desc: "Connect port spi_mosi from port group spi9 to this pad." }
                      { value: "29", name: "port_spi9_spi_sck", desc: "Connect port spi_sck from port group spi9 to this pad." }
                  ]
              }
          ]
      }

      {
          name: PAD_IO_E_08_CFG
          desc: '''
            Pad signal configuration.
          '''
          swaccess: "rw"
          fields: [
            {
                bits: "0"
                name: chip2pad
                desc: '''
                     The signal that connects to the pads TX driver
                '''
                swaccess: "rw"
                hwaccess: "hro"
                resval: "0"
            },
            {
                bits: "1"
                name: oen
                desc: '''
                     Output enable signal, active low
                '''
                swaccess: "rw"
                hwaccess: "hro"
                resval: "1"
            },
          ]
      }

       {
          name: PAD_IO_E_08_MUX_SEL
          desc: '''
              Pad signal port multiplex selection for pad pad_io_e_08. The programmed value defines which port
              is connected to the pad.
          '''
          swaccess: "rw"
          hwaccess: "hro"
          resval: 0
          fields: [
              {
                  bits: "4:0"
                  enum: [
                      { value: "0", name: "register", desc: "Connects the Pad to the internal configuration register."}
                      { value: "1", name: "port_CAN2_CAN_can1_rx", desc: "Connect port can1_rx from port group CAN2_CAN to this pad." }
                      { value: "2", name: "port_CAN2_CAN_can1_tx", desc: "Connect port can1_tx from port group CAN2_CAN to this pad." }
                      { value: "3", name: "port_CAN2_CAN_can2_rx", desc: "Connect port can2_rx from port group CAN2_CAN to this pad." }
                      { value: "4", name: "port_CAN2_CAN_can2_tx", desc: "Connect port can2_tx from port group CAN2_CAN to this pad." }
                      { value: "5", name: "port_cam0_cam_data0_i", desc: "Connect port cam_data0_i from port group cam0 to this pad." }
                      { value: "6", name: "port_cam0_cam_data1_i", desc: "Connect port cam_data1_i from port group cam0 to this pad." }
                      { value: "7", name: "port_cam0_cam_data2_i", desc: "Connect port cam_data2_i from port group cam0 to this pad." }
                      { value: "8", name: "port_cam0_cam_data3_i", desc: "Connect port cam_data3_i from port group cam0 to this pad." }
                      { value: "9", name: "port_cam0_cam_data4_i", desc: "Connect port cam_data4_i from port group cam0 to this pad." }
                      { value: "10", name: "port_cam0_cam_data5_i", desc: "Connect port cam_data5_i from port group cam0 to this pad." }
                      { value: "11", name: "port_cam0_cam_data6_i", desc: "Connect port cam_data6_i from port group cam0 to this pad." }
                      { value: "12", name: "port_cam0_cam_data7_i", desc: "Connect port cam_data7_i from port group cam0 to this pad." }
                      { value: "13", name: "port_cam0_cam_hsync", desc: "Connect port cam_hsync from port group cam0 to this pad." }
                      { value: "14", name: "port_cam0_cam_pclk", desc: "Connect port cam_pclk from port group cam0 to this pad." }
                      { value: "15", name: "port_cam0_cam_vsync", desc: "Connect port cam_vsync from port group cam0 to this pad." }
                      { value: "16", name: "port_i2c3_i2c_scl", desc: "Connect port i2c_scl from port group i2c3 to this pad." }
                      { value: "17", name: "port_i2c3_i2c_sda", desc: "Connect port i2c_sda from port group i2c3 to this pad." }
                      { value: "18", name: "port_spi7_spi_cs", desc: "Connect port spi_cs from port group spi7 to this pad." }
                      { value: "19", name: "port_spi7_spi_miso", desc: "Connect port spi_miso from port group spi7 to this pad." }
                      { value: "20", name: "port_spi7_spi_mosi", desc: "Connect port spi_mosi from port group spi7 to this pad." }
                      { value: "21", name: "port_spi7_spi_sck", desc: "Connect port spi_sck from port group spi7 to this pad." }
                      { value: "22", name: "port_spi8_spi_cs", desc: "Connect port spi_cs from port group spi8 to this pad." }
                      { value: "23", name: "port_spi8_spi_miso", desc: "Connect port spi_miso from port group spi8 to this pad." }
                      { value: "24", name: "port_spi8_spi_mosi", desc: "Connect port spi_mosi from port group spi8 to this pad." }
                      { value: "25", name: "port_spi8_spi_sck", desc: "Connect port spi_sck from port group spi8 to this pad." }
                      { value: "26", name: "port_spi9_spi_cs", desc: "Connect port spi_cs from port group spi9 to this pad." }
                      { value: "27", name: "port_spi9_spi_miso", desc: "Connect port spi_miso from port group spi9 to this pad." }
                      { value: "28", name: "port_spi9_spi_mosi", desc: "Connect port spi_mosi from port group spi9 to this pad." }
                      { value: "29", name: "port_spi9_spi_sck", desc: "Connect port spi_sck from port group spi9 to this pad." }
                  ]
              }
          ]
      }

      {
          name: PAD_IO_E_09_CFG
          desc: '''
            Pad signal configuration.
          '''
          swaccess: "rw"
          fields: [
            {
                bits: "0"
                name: chip2pad
                desc: '''
                     The signal that connects to the pads TX driver
                '''
                swaccess: "rw"
                hwaccess: "hro"
                resval: "0"
            },
            {
                bits: "1"
                name: oen
                desc: '''
                     Output enable signal, active low
                '''
                swaccess: "rw"
                hwaccess: "hro"
                resval: "1"
            },
          ]
      }

       {
          name: PAD_IO_E_09_MUX_SEL
          desc: '''
              Pad signal port multiplex selection for pad pad_io_e_09. The programmed value defines which port
              is connected to the pad.
          '''
          swaccess: "rw"
          hwaccess: "hro"
          resval: 0
          fields: [
              {
                  bits: "4:0"
                  enum: [
                      { value: "0", name: "register", desc: "Connects the Pad to the internal configuration register."}
                      { value: "1", name: "port_CAN2_CAN_can1_rx", desc: "Connect port can1_rx from port group CAN2_CAN to this pad." }
                      { value: "2", name: "port_CAN2_CAN_can1_tx", desc: "Connect port can1_tx from port group CAN2_CAN to this pad." }
                      { value: "3", name: "port_CAN2_CAN_can2_rx", desc: "Connect port can2_rx from port group CAN2_CAN to this pad." }
                      { value: "4", name: "port_CAN2_CAN_can2_tx", desc: "Connect port can2_tx from port group CAN2_CAN to this pad." }
                      { value: "5", name: "port_cam0_cam_data0_i", desc: "Connect port cam_data0_i from port group cam0 to this pad." }
                      { value: "6", name: "port_cam0_cam_data1_i", desc: "Connect port cam_data1_i from port group cam0 to this pad." }
                      { value: "7", name: "port_cam0_cam_data2_i", desc: "Connect port cam_data2_i from port group cam0 to this pad." }
                      { value: "8", name: "port_cam0_cam_data3_i", desc: "Connect port cam_data3_i from port group cam0 to this pad." }
                      { value: "9", name: "port_cam0_cam_data4_i", desc: "Connect port cam_data4_i from port group cam0 to this pad." }
                      { value: "10", name: "port_cam0_cam_data5_i", desc: "Connect port cam_data5_i from port group cam0 to this pad." }
                      { value: "11", name: "port_cam0_cam_data6_i", desc: "Connect port cam_data6_i from port group cam0 to this pad." }
                      { value: "12", name: "port_cam0_cam_data7_i", desc: "Connect port cam_data7_i from port group cam0 to this pad." }
                      { value: "13", name: "port_cam0_cam_hsync", desc: "Connect port cam_hsync from port group cam0 to this pad." }
                      { value: "14", name: "port_cam0_cam_pclk", desc: "Connect port cam_pclk from port group cam0 to this pad." }
                      { value: "15", name: "port_cam0_cam_vsync", desc: "Connect port cam_vsync from port group cam0 to this pad." }
                      { value: "16", name: "port_i2c3_i2c_scl", desc: "Connect port i2c_scl from port group i2c3 to this pad." }
                      { value: "17", name: "port_i2c3_i2c_sda", desc: "Connect port i2c_sda from port group i2c3 to this pad." }
                      { value: "18", name: "port_spi7_spi_cs", desc: "Connect port spi_cs from port group spi7 to this pad." }
                      { value: "19", name: "port_spi7_spi_miso", desc: "Connect port spi_miso from port group spi7 to this pad." }
                      { value: "20", name: "port_spi7_spi_mosi", desc: "Connect port spi_mosi from port group spi7 to this pad." }
                      { value: "21", name: "port_spi7_spi_sck", desc: "Connect port spi_sck from port group spi7 to this pad." }
                      { value: "22", name: "port_spi8_spi_cs", desc: "Connect port spi_cs from port group spi8 to this pad." }
                      { value: "23", name: "port_spi8_spi_miso", desc: "Connect port spi_miso from port group spi8 to this pad." }
                      { value: "24", name: "port_spi8_spi_mosi", desc: "Connect port spi_mosi from port group spi8 to this pad." }
                      { value: "25", name: "port_spi8_spi_sck", desc: "Connect port spi_sck from port group spi8 to this pad." }
                      { value: "26", name: "port_spi9_spi_cs", desc: "Connect port spi_cs from port group spi9 to this pad." }
                      { value: "27", name: "port_spi9_spi_miso", desc: "Connect port spi_miso from port group spi9 to this pad." }
                      { value: "28", name: "port_spi9_spi_mosi", desc: "Connect port spi_mosi from port group spi9 to this pad." }
                      { value: "29", name: "port_spi9_spi_sck", desc: "Connect port spi_sck from port group spi9 to this pad." }
                  ]
              }
          ]
      }

      {
          name: PAD_IO_E_10_CFG
          desc: '''
            Pad signal configuration.
          '''
          swaccess: "rw"
          fields: [
            {
                bits: "0"
                name: chip2pad
                desc: '''
                     The signal that connects to the pads TX driver
                '''
                swaccess: "rw"
                hwaccess: "hro"
                resval: "0"
            },
            {
                bits: "1"
                name: oen
                desc: '''
                     Output enable signal, active low
                '''
                swaccess: "rw"
                hwaccess: "hro"
                resval: "1"
            },
          ]
      }

       {
          name: PAD_IO_E_10_MUX_SEL
          desc: '''
              Pad signal port multiplex selection for pad pad_io_e_10. The programmed value defines which port
              is connected to the pad.
          '''
          swaccess: "rw"
          hwaccess: "hro"
          resval: 0
          fields: [
              {
                  bits: "4:0"
                  enum: [
                      { value: "0", name: "register", desc: "Connects the Pad to the internal configuration register."}
                      { value: "1", name: "port_CAN2_CAN_can1_rx", desc: "Connect port can1_rx from port group CAN2_CAN to this pad." }
                      { value: "2", name: "port_CAN2_CAN_can1_tx", desc: "Connect port can1_tx from port group CAN2_CAN to this pad." }
                      { value: "3", name: "port_CAN2_CAN_can2_rx", desc: "Connect port can2_rx from port group CAN2_CAN to this pad." }
                      { value: "4", name: "port_CAN2_CAN_can2_tx", desc: "Connect port can2_tx from port group CAN2_CAN to this pad." }
                      { value: "5", name: "port_cam0_cam_data0_i", desc: "Connect port cam_data0_i from port group cam0 to this pad." }
                      { value: "6", name: "port_cam0_cam_data1_i", desc: "Connect port cam_data1_i from port group cam0 to this pad." }
                      { value: "7", name: "port_cam0_cam_data2_i", desc: "Connect port cam_data2_i from port group cam0 to this pad." }
                      { value: "8", name: "port_cam0_cam_data3_i", desc: "Connect port cam_data3_i from port group cam0 to this pad." }
                      { value: "9", name: "port_cam0_cam_data4_i", desc: "Connect port cam_data4_i from port group cam0 to this pad." }
                      { value: "10", name: "port_cam0_cam_data5_i", desc: "Connect port cam_data5_i from port group cam0 to this pad." }
                      { value: "11", name: "port_cam0_cam_data6_i", desc: "Connect port cam_data6_i from port group cam0 to this pad." }
                      { value: "12", name: "port_cam0_cam_data7_i", desc: "Connect port cam_data7_i from port group cam0 to this pad." }
                      { value: "13", name: "port_cam0_cam_hsync", desc: "Connect port cam_hsync from port group cam0 to this pad." }
                      { value: "14", name: "port_cam0_cam_pclk", desc: "Connect port cam_pclk from port group cam0 to this pad." }
                      { value: "15", name: "port_cam0_cam_vsync", desc: "Connect port cam_vsync from port group cam0 to this pad." }
                      { value: "16", name: "port_i2c3_i2c_scl", desc: "Connect port i2c_scl from port group i2c3 to this pad." }
                      { value: "17", name: "port_i2c3_i2c_sda", desc: "Connect port i2c_sda from port group i2c3 to this pad." }
                      { value: "18", name: "port_spi7_spi_cs", desc: "Connect port spi_cs from port group spi7 to this pad." }
                      { value: "19", name: "port_spi7_spi_miso", desc: "Connect port spi_miso from port group spi7 to this pad." }
                      { value: "20", name: "port_spi7_spi_mosi", desc: "Connect port spi_mosi from port group spi7 to this pad." }
                      { value: "21", name: "port_spi7_spi_sck", desc: "Connect port spi_sck from port group spi7 to this pad." }
                      { value: "22", name: "port_spi8_spi_cs", desc: "Connect port spi_cs from port group spi8 to this pad." }
                      { value: "23", name: "port_spi8_spi_miso", desc: "Connect port spi_miso from port group spi8 to this pad." }
                      { value: "24", name: "port_spi8_spi_mosi", desc: "Connect port spi_mosi from port group spi8 to this pad." }
                      { value: "25", name: "port_spi8_spi_sck", desc: "Connect port spi_sck from port group spi8 to this pad." }
                      { value: "26", name: "port_spi9_spi_cs", desc: "Connect port spi_cs from port group spi9 to this pad." }
                      { value: "27", name: "port_spi9_spi_miso", desc: "Connect port spi_miso from port group spi9 to this pad." }
                      { value: "28", name: "port_spi9_spi_mosi", desc: "Connect port spi_mosi from port group spi9 to this pad." }
                      { value: "29", name: "port_spi9_spi_sck", desc: "Connect port spi_sck from port group spi9 to this pad." }
                  ]
              }
          ]
      }

      {
          name: PAD_IO_E_11_CFG
          desc: '''
            Pad signal configuration.
          '''
          swaccess: "rw"
          fields: [
            {
                bits: "0"
                name: chip2pad
                desc: '''
                     The signal that connects to the pads TX driver
                '''
                swaccess: "rw"
                hwaccess: "hro"
                resval: "0"
            },
            {
                bits: "1"
                name: oen
                desc: '''
                     Output enable signal, active low
                '''
                swaccess: "rw"
                hwaccess: "hro"
                resval: "1"
            },
          ]
      }

       {
          name: PAD_IO_E_11_MUX_SEL
          desc: '''
              Pad signal port multiplex selection for pad pad_io_e_11. The programmed value defines which port
              is connected to the pad.
          '''
          swaccess: "rw"
          hwaccess: "hro"
          resval: 0
          fields: [
              {
                  bits: "4:0"
                  enum: [
                      { value: "0", name: "register", desc: "Connects the Pad to the internal configuration register."}
                      { value: "1", name: "port_CAN2_CAN_can1_rx", desc: "Connect port can1_rx from port group CAN2_CAN to this pad." }
                      { value: "2", name: "port_CAN2_CAN_can1_tx", desc: "Connect port can1_tx from port group CAN2_CAN to this pad." }
                      { value: "3", name: "port_CAN2_CAN_can2_rx", desc: "Connect port can2_rx from port group CAN2_CAN to this pad." }
                      { value: "4", name: "port_CAN2_CAN_can2_tx", desc: "Connect port can2_tx from port group CAN2_CAN to this pad." }
                      { value: "5", name: "port_cam0_cam_data0_i", desc: "Connect port cam_data0_i from port group cam0 to this pad." }
                      { value: "6", name: "port_cam0_cam_data1_i", desc: "Connect port cam_data1_i from port group cam0 to this pad." }
                      { value: "7", name: "port_cam0_cam_data2_i", desc: "Connect port cam_data2_i from port group cam0 to this pad." }
                      { value: "8", name: "port_cam0_cam_data3_i", desc: "Connect port cam_data3_i from port group cam0 to this pad." }
                      { value: "9", name: "port_cam0_cam_data4_i", desc: "Connect port cam_data4_i from port group cam0 to this pad." }
                      { value: "10", name: "port_cam0_cam_data5_i", desc: "Connect port cam_data5_i from port group cam0 to this pad." }
                      { value: "11", name: "port_cam0_cam_data6_i", desc: "Connect port cam_data6_i from port group cam0 to this pad." }
                      { value: "12", name: "port_cam0_cam_data7_i", desc: "Connect port cam_data7_i from port group cam0 to this pad." }
                      { value: "13", name: "port_cam0_cam_hsync", desc: "Connect port cam_hsync from port group cam0 to this pad." }
                      { value: "14", name: "port_cam0_cam_pclk", desc: "Connect port cam_pclk from port group cam0 to this pad." }
                      { value: "15", name: "port_cam0_cam_vsync", desc: "Connect port cam_vsync from port group cam0 to this pad." }
                      { value: "16", name: "port_i2c3_i2c_scl", desc: "Connect port i2c_scl from port group i2c3 to this pad." }
                      { value: "17", name: "port_i2c3_i2c_sda", desc: "Connect port i2c_sda from port group i2c3 to this pad." }
                      { value: "18", name: "port_spi7_spi_cs", desc: "Connect port spi_cs from port group spi7 to this pad." }
                      { value: "19", name: "port_spi7_spi_miso", desc: "Connect port spi_miso from port group spi7 to this pad." }
                      { value: "20", name: "port_spi7_spi_mosi", desc: "Connect port spi_mosi from port group spi7 to this pad." }
                      { value: "21", name: "port_spi7_spi_sck", desc: "Connect port spi_sck from port group spi7 to this pad." }
                      { value: "22", name: "port_spi8_spi_cs", desc: "Connect port spi_cs from port group spi8 to this pad." }
                      { value: "23", name: "port_spi8_spi_miso", desc: "Connect port spi_miso from port group spi8 to this pad." }
                      { value: "24", name: "port_spi8_spi_mosi", desc: "Connect port spi_mosi from port group spi8 to this pad." }
                      { value: "25", name: "port_spi8_spi_sck", desc: "Connect port spi_sck from port group spi8 to this pad." }
                      { value: "26", name: "port_spi9_spi_cs", desc: "Connect port spi_cs from port group spi9 to this pad." }
                      { value: "27", name: "port_spi9_spi_miso", desc: "Connect port spi_miso from port group spi9 to this pad." }
                      { value: "28", name: "port_spi9_spi_mosi", desc: "Connect port spi_mosi from port group spi9 to this pad." }
                      { value: "29", name: "port_spi9_spi_sck", desc: "Connect port spi_sck from port group spi9 to this pad." }
                  ]
              }
          ]
      }

      {
          name: PAD_IO_E_12_CFG
          desc: '''
            Pad signal configuration.
          '''
          swaccess: "rw"
          fields: [
            {
                bits: "0"
                name: chip2pad
                desc: '''
                     The signal that connects to the pads TX driver
                '''
                swaccess: "rw"
                hwaccess: "hro"
                resval: "0"
            },
            {
                bits: "1"
                name: oen
                desc: '''
                     Output enable signal, active low
                '''
                swaccess: "rw"
                hwaccess: "hro"
                resval: "1"
            },
          ]
      }

       {
          name: PAD_IO_E_12_MUX_SEL
          desc: '''
              Pad signal port multiplex selection for pad pad_io_e_12. The programmed value defines which port
              is connected to the pad.
          '''
          swaccess: "rw"
          hwaccess: "hro"
          resval: 0
          fields: [
              {
                  bits: "4:0"
                  enum: [
                      { value: "0", name: "register", desc: "Connects the Pad to the internal configuration register."}
                      { value: "1", name: "port_CAN2_CAN_can1_rx", desc: "Connect port can1_rx from port group CAN2_CAN to this pad." }
                      { value: "2", name: "port_CAN2_CAN_can1_tx", desc: "Connect port can1_tx from port group CAN2_CAN to this pad." }
                      { value: "3", name: "port_CAN2_CAN_can2_rx", desc: "Connect port can2_rx from port group CAN2_CAN to this pad." }
                      { value: "4", name: "port_CAN2_CAN_can2_tx", desc: "Connect port can2_tx from port group CAN2_CAN to this pad." }
                      { value: "5", name: "port_cam0_cam_data0_i", desc: "Connect port cam_data0_i from port group cam0 to this pad." }
                      { value: "6", name: "port_cam0_cam_data1_i", desc: "Connect port cam_data1_i from port group cam0 to this pad." }
                      { value: "7", name: "port_cam0_cam_data2_i", desc: "Connect port cam_data2_i from port group cam0 to this pad." }
                      { value: "8", name: "port_cam0_cam_data3_i", desc: "Connect port cam_data3_i from port group cam0 to this pad." }
                      { value: "9", name: "port_cam0_cam_data4_i", desc: "Connect port cam_data4_i from port group cam0 to this pad." }
                      { value: "10", name: "port_cam0_cam_data5_i", desc: "Connect port cam_data5_i from port group cam0 to this pad." }
                      { value: "11", name: "port_cam0_cam_data6_i", desc: "Connect port cam_data6_i from port group cam0 to this pad." }
                      { value: "12", name: "port_cam0_cam_data7_i", desc: "Connect port cam_data7_i from port group cam0 to this pad." }
                      { value: "13", name: "port_cam0_cam_hsync", desc: "Connect port cam_hsync from port group cam0 to this pad." }
                      { value: "14", name: "port_cam0_cam_pclk", desc: "Connect port cam_pclk from port group cam0 to this pad." }
                      { value: "15", name: "port_cam0_cam_vsync", desc: "Connect port cam_vsync from port group cam0 to this pad." }
                      { value: "16", name: "port_i2c3_i2c_scl", desc: "Connect port i2c_scl from port group i2c3 to this pad." }
                      { value: "17", name: "port_i2c3_i2c_sda", desc: "Connect port i2c_sda from port group i2c3 to this pad." }
                      { value: "18", name: "port_spi7_spi_cs", desc: "Connect port spi_cs from port group spi7 to this pad." }
                      { value: "19", name: "port_spi7_spi_miso", desc: "Connect port spi_miso from port group spi7 to this pad." }
                      { value: "20", name: "port_spi7_spi_mosi", desc: "Connect port spi_mosi from port group spi7 to this pad." }
                      { value: "21", name: "port_spi7_spi_sck", desc: "Connect port spi_sck from port group spi7 to this pad." }
                      { value: "22", name: "port_spi8_spi_cs", desc: "Connect port spi_cs from port group spi8 to this pad." }
                      { value: "23", name: "port_spi8_spi_miso", desc: "Connect port spi_miso from port group spi8 to this pad." }
                      { value: "24", name: "port_spi8_spi_mosi", desc: "Connect port spi_mosi from port group spi8 to this pad." }
                      { value: "25", name: "port_spi8_spi_sck", desc: "Connect port spi_sck from port group spi8 to this pad." }
                      { value: "26", name: "port_spi9_spi_cs", desc: "Connect port spi_cs from port group spi9 to this pad." }
                      { value: "27", name: "port_spi9_spi_miso", desc: "Connect port spi_miso from port group spi9 to this pad." }
                      { value: "28", name: "port_spi9_spi_mosi", desc: "Connect port spi_mosi from port group spi9 to this pad." }
                      { value: "29", name: "port_spi9_spi_sck", desc: "Connect port spi_sck from port group spi9 to this pad." }
                  ]
              }
          ]
      }

      {
          name: PAD_IO_E_13_CFG
          desc: '''
            Pad signal configuration.
          '''
          swaccess: "rw"
          fields: [
            {
                bits: "0"
                name: chip2pad
                desc: '''
                     The signal that connects to the pads TX driver
                '''
                swaccess: "rw"
                hwaccess: "hro"
                resval: "0"
            },
            {
                bits: "1"
                name: oen
                desc: '''
                     Output enable signal, active low
                '''
                swaccess: "rw"
                hwaccess: "hro"
                resval: "1"
            },
          ]
      }

       {
          name: PAD_IO_E_13_MUX_SEL
          desc: '''
              Pad signal port multiplex selection for pad pad_io_e_13. The programmed value defines which port
              is connected to the pad.
          '''
          swaccess: "rw"
          hwaccess: "hro"
          resval: 0
          fields: [
              {
                  bits: "4:0"
                  enum: [
                      { value: "0", name: "register", desc: "Connects the Pad to the internal configuration register."}
                      { value: "1", name: "port_CAN2_CAN_can1_rx", desc: "Connect port can1_rx from port group CAN2_CAN to this pad." }
                      { value: "2", name: "port_CAN2_CAN_can1_tx", desc: "Connect port can1_tx from port group CAN2_CAN to this pad." }
                      { value: "3", name: "port_CAN2_CAN_can2_rx", desc: "Connect port can2_rx from port group CAN2_CAN to this pad." }
                      { value: "4", name: "port_CAN2_CAN_can2_tx", desc: "Connect port can2_tx from port group CAN2_CAN to this pad." }
                      { value: "5", name: "port_cam0_cam_data0_i", desc: "Connect port cam_data0_i from port group cam0 to this pad." }
                      { value: "6", name: "port_cam0_cam_data1_i", desc: "Connect port cam_data1_i from port group cam0 to this pad." }
                      { value: "7", name: "port_cam0_cam_data2_i", desc: "Connect port cam_data2_i from port group cam0 to this pad." }
                      { value: "8", name: "port_cam0_cam_data3_i", desc: "Connect port cam_data3_i from port group cam0 to this pad." }
                      { value: "9", name: "port_cam0_cam_data4_i", desc: "Connect port cam_data4_i from port group cam0 to this pad." }
                      { value: "10", name: "port_cam0_cam_data5_i", desc: "Connect port cam_data5_i from port group cam0 to this pad." }
                      { value: "11", name: "port_cam0_cam_data6_i", desc: "Connect port cam_data6_i from port group cam0 to this pad." }
                      { value: "12", name: "port_cam0_cam_data7_i", desc: "Connect port cam_data7_i from port group cam0 to this pad." }
                      { value: "13", name: "port_cam0_cam_hsync", desc: "Connect port cam_hsync from port group cam0 to this pad." }
                      { value: "14", name: "port_cam0_cam_pclk", desc: "Connect port cam_pclk from port group cam0 to this pad." }
                      { value: "15", name: "port_cam0_cam_vsync", desc: "Connect port cam_vsync from port group cam0 to this pad." }
                      { value: "16", name: "port_i2c3_i2c_scl", desc: "Connect port i2c_scl from port group i2c3 to this pad." }
                      { value: "17", name: "port_i2c3_i2c_sda", desc: "Connect port i2c_sda from port group i2c3 to this pad." }
                      { value: "18", name: "port_spi7_spi_cs", desc: "Connect port spi_cs from port group spi7 to this pad." }
                      { value: "19", name: "port_spi7_spi_miso", desc: "Connect port spi_miso from port group spi7 to this pad." }
                      { value: "20", name: "port_spi7_spi_mosi", desc: "Connect port spi_mosi from port group spi7 to this pad." }
                      { value: "21", name: "port_spi7_spi_sck", desc: "Connect port spi_sck from port group spi7 to this pad." }
                      { value: "22", name: "port_spi8_spi_cs", desc: "Connect port spi_cs from port group spi8 to this pad." }
                      { value: "23", name: "port_spi8_spi_miso", desc: "Connect port spi_miso from port group spi8 to this pad." }
                      { value: "24", name: "port_spi8_spi_mosi", desc: "Connect port spi_mosi from port group spi8 to this pad." }
                      { value: "25", name: "port_spi8_spi_sck", desc: "Connect port spi_sck from port group spi8 to this pad." }
                      { value: "26", name: "port_spi9_spi_cs", desc: "Connect port spi_cs from port group spi9 to this pad." }
                      { value: "27", name: "port_spi9_spi_miso", desc: "Connect port spi_miso from port group spi9 to this pad." }
                      { value: "28", name: "port_spi9_spi_mosi", desc: "Connect port spi_mosi from port group spi9 to this pad." }
                      { value: "29", name: "port_spi9_spi_sck", desc: "Connect port spi_sck from port group spi9 to this pad." }
                  ]
              }
          ]
      }

      {
          name: PAD_IO_E_14_CFG
          desc: '''
            Pad signal configuration.
          '''
          swaccess: "rw"
          fields: [
            {
                bits: "0"
                name: chip2pad
                desc: '''
                     The signal that connects to the pads TX driver
                '''
                swaccess: "rw"
                hwaccess: "hro"
                resval: "0"
            },
            {
                bits: "1"
                name: oen
                desc: '''
                     Output enable signal, active low
                '''
                swaccess: "rw"
                hwaccess: "hro"
                resval: "1"
            },
          ]
      }

       {
          name: PAD_IO_E_14_MUX_SEL
          desc: '''
              Pad signal port multiplex selection for pad pad_io_e_14. The programmed value defines which port
              is connected to the pad.
          '''
          swaccess: "rw"
          hwaccess: "hro"
          resval: 0
          fields: [
              {
                  bits: "4:0"
                  enum: [
                      { value: "0", name: "register", desc: "Connects the Pad to the internal configuration register."}
                      { value: "1", name: "port_CAN2_CAN_can1_rx", desc: "Connect port can1_rx from port group CAN2_CAN to this pad." }
                      { value: "2", name: "port_CAN2_CAN_can1_tx", desc: "Connect port can1_tx from port group CAN2_CAN to this pad." }
                      { value: "3", name: "port_CAN2_CAN_can2_rx", desc: "Connect port can2_rx from port group CAN2_CAN to this pad." }
                      { value: "4", name: "port_CAN2_CAN_can2_tx", desc: "Connect port can2_tx from port group CAN2_CAN to this pad." }
                      { value: "5", name: "port_cam0_cam_data0_i", desc: "Connect port cam_data0_i from port group cam0 to this pad." }
                      { value: "6", name: "port_cam0_cam_data1_i", desc: "Connect port cam_data1_i from port group cam0 to this pad." }
                      { value: "7", name: "port_cam0_cam_data2_i", desc: "Connect port cam_data2_i from port group cam0 to this pad." }
                      { value: "8", name: "port_cam0_cam_data3_i", desc: "Connect port cam_data3_i from port group cam0 to this pad." }
                      { value: "9", name: "port_cam0_cam_data4_i", desc: "Connect port cam_data4_i from port group cam0 to this pad." }
                      { value: "10", name: "port_cam0_cam_data5_i", desc: "Connect port cam_data5_i from port group cam0 to this pad." }
                      { value: "11", name: "port_cam0_cam_data6_i", desc: "Connect port cam_data6_i from port group cam0 to this pad." }
                      { value: "12", name: "port_cam0_cam_data7_i", desc: "Connect port cam_data7_i from port group cam0 to this pad." }
                      { value: "13", name: "port_cam0_cam_hsync", desc: "Connect port cam_hsync from port group cam0 to this pad." }
                      { value: "14", name: "port_cam0_cam_pclk", desc: "Connect port cam_pclk from port group cam0 to this pad." }
                      { value: "15", name: "port_cam0_cam_vsync", desc: "Connect port cam_vsync from port group cam0 to this pad." }
                      { value: "16", name: "port_i2c3_i2c_scl", desc: "Connect port i2c_scl from port group i2c3 to this pad." }
                      { value: "17", name: "port_i2c3_i2c_sda", desc: "Connect port i2c_sda from port group i2c3 to this pad." }
                      { value: "18", name: "port_spi7_spi_cs", desc: "Connect port spi_cs from port group spi7 to this pad." }
                      { value: "19", name: "port_spi7_spi_miso", desc: "Connect port spi_miso from port group spi7 to this pad." }
                      { value: "20", name: "port_spi7_spi_mosi", desc: "Connect port spi_mosi from port group spi7 to this pad." }
                      { value: "21", name: "port_spi7_spi_sck", desc: "Connect port spi_sck from port group spi7 to this pad." }
                      { value: "22", name: "port_spi8_spi_cs", desc: "Connect port spi_cs from port group spi8 to this pad." }
                      { value: "23", name: "port_spi8_spi_miso", desc: "Connect port spi_miso from port group spi8 to this pad." }
                      { value: "24", name: "port_spi8_spi_mosi", desc: "Connect port spi_mosi from port group spi8 to this pad." }
                      { value: "25", name: "port_spi8_spi_sck", desc: "Connect port spi_sck from port group spi8 to this pad." }
                      { value: "26", name: "port_spi9_spi_cs", desc: "Connect port spi_cs from port group spi9 to this pad." }
                      { value: "27", name: "port_spi9_spi_miso", desc: "Connect port spi_miso from port group spi9 to this pad." }
                      { value: "28", name: "port_spi9_spi_mosi", desc: "Connect port spi_mosi from port group spi9 to this pad." }
                      { value: "29", name: "port_spi9_spi_sck", desc: "Connect port spi_sck from port group spi9 to this pad." }
                  ]
              }
          ]
      }

      {
          name: PAD_IO_F_00_CFG
          desc: '''
            Pad signal configuration.
          '''
          swaccess: "rw"
          fields: [
            {
                bits: "0"
                name: chip2pad
                desc: '''
                     The signal that connects to the pads TX driver
                '''
                swaccess: "rw"
                hwaccess: "hro"
                resval: "0"
            },
            {
                bits: "1"
                name: oen
                desc: '''
                     Output enable signal, active low
                '''
                swaccess: "rw"
                hwaccess: "hro"
                resval: "1"
            },
          ]
      }

       {
          name: PAD_IO_F_00_MUX_SEL
          desc: '''
              Pad signal port multiplex selection for pad pad_io_f_00. The programmed value defines which port
              is connected to the pad.
          '''
          swaccess: "rw"
          hwaccess: "hro"
          resval: 0
          fields: [
              {
                  bits: "4:0"
                  enum: [
                      { value: "0", name: "register", desc: "Connects the Pad to the internal configuration register."}
                      { value: "1", name: "port_cam1_cam_data0_i", desc: "Connect port cam_data0_i from port group cam1 to this pad." }
                      { value: "2", name: "port_cam1_cam_data1_i", desc: "Connect port cam_data1_i from port group cam1 to this pad." }
                      { value: "3", name: "port_cam1_cam_data2_i", desc: "Connect port cam_data2_i from port group cam1 to this pad." }
                      { value: "4", name: "port_cam1_cam_data3_i", desc: "Connect port cam_data3_i from port group cam1 to this pad." }
                      { value: "5", name: "port_cam1_cam_data4_i", desc: "Connect port cam_data4_i from port group cam1 to this pad." }
                      { value: "6", name: "port_cam1_cam_data5_i", desc: "Connect port cam_data5_i from port group cam1 to this pad." }
                      { value: "7", name: "port_cam1_cam_data6_i", desc: "Connect port cam_data6_i from port group cam1 to this pad." }
                      { value: "8", name: "port_cam1_cam_data7_i", desc: "Connect port cam_data7_i from port group cam1 to this pad." }
                      { value: "9", name: "port_cam1_cam_hsync", desc: "Connect port cam_hsync from port group cam1 to this pad." }
                      { value: "10", name: "port_cam1_cam_pclk", desc: "Connect port cam_pclk from port group cam1 to this pad." }
                      { value: "11", name: "port_cam1_cam_vsync", desc: "Connect port cam_vsync from port group cam1 to this pad." }
                      { value: "12", name: "port_i2c4_i2c_scl", desc: "Connect port i2c_scl from port group i2c4 to this pad." }
                      { value: "13", name: "port_i2c4_i2c_sda", desc: "Connect port i2c_sda from port group i2c4 to this pad." }
                      { value: "14", name: "port_spi10_spi_cs", desc: "Connect port spi_cs from port group spi10 to this pad." }
                      { value: "15", name: "port_spi10_spi_miso", desc: "Connect port spi_miso from port group spi10 to this pad." }
                      { value: "16", name: "port_spi10_spi_mosi", desc: "Connect port spi_mosi from port group spi10 to this pad." }
                      { value: "17", name: "port_spi10_spi_sck", desc: "Connect port spi_sck from port group spi10 to this pad." }
                      { value: "18", name: "port_uart2_uart_rx", desc: "Connect port uart_rx from port group uart2 to this pad." }
                      { value: "19", name: "port_uart2_uart_tx", desc: "Connect port uart_tx from port group uart2 to this pad." }
                      { value: "20", name: "port_uart3_uart_rx", desc: "Connect port uart_rx from port group uart3 to this pad." }
                      { value: "21", name: "port_uart3_uart_tx", desc: "Connect port uart_tx from port group uart3 to this pad." }
                  ]
              }
          ]
      }

      {
          name: PAD_IO_F_01_CFG
          desc: '''
            Pad signal configuration.
          '''
          swaccess: "rw"
          fields: [
            {
                bits: "0"
                name: chip2pad
                desc: '''
                     The signal that connects to the pads TX driver
                '''
                swaccess: "rw"
                hwaccess: "hro"
                resval: "0"
            },
            {
                bits: "1"
                name: oen
                desc: '''
                     Output enable signal, active low
                '''
                swaccess: "rw"
                hwaccess: "hro"
                resval: "1"
            },
          ]
      }

       {
          name: PAD_IO_F_01_MUX_SEL
          desc: '''
              Pad signal port multiplex selection for pad pad_io_f_01. The programmed value defines which port
              is connected to the pad.
          '''
          swaccess: "rw"
          hwaccess: "hro"
          resval: 0
          fields: [
              {
                  bits: "4:0"
                  enum: [
                      { value: "0", name: "register", desc: "Connects the Pad to the internal configuration register."}
                      { value: "1", name: "port_cam1_cam_data0_i", desc: "Connect port cam_data0_i from port group cam1 to this pad." }
                      { value: "2", name: "port_cam1_cam_data1_i", desc: "Connect port cam_data1_i from port group cam1 to this pad." }
                      { value: "3", name: "port_cam1_cam_data2_i", desc: "Connect port cam_data2_i from port group cam1 to this pad." }
                      { value: "4", name: "port_cam1_cam_data3_i", desc: "Connect port cam_data3_i from port group cam1 to this pad." }
                      { value: "5", name: "port_cam1_cam_data4_i", desc: "Connect port cam_data4_i from port group cam1 to this pad." }
                      { value: "6", name: "port_cam1_cam_data5_i", desc: "Connect port cam_data5_i from port group cam1 to this pad." }
                      { value: "7", name: "port_cam1_cam_data6_i", desc: "Connect port cam_data6_i from port group cam1 to this pad." }
                      { value: "8", name: "port_cam1_cam_data7_i", desc: "Connect port cam_data7_i from port group cam1 to this pad." }
                      { value: "9", name: "port_cam1_cam_hsync", desc: "Connect port cam_hsync from port group cam1 to this pad." }
                      { value: "10", name: "port_cam1_cam_pclk", desc: "Connect port cam_pclk from port group cam1 to this pad." }
                      { value: "11", name: "port_cam1_cam_vsync", desc: "Connect port cam_vsync from port group cam1 to this pad." }
                      { value: "12", name: "port_i2c4_i2c_scl", desc: "Connect port i2c_scl from port group i2c4 to this pad." }
                      { value: "13", name: "port_i2c4_i2c_sda", desc: "Connect port i2c_sda from port group i2c4 to this pad." }
                      { value: "14", name: "port_spi10_spi_cs", desc: "Connect port spi_cs from port group spi10 to this pad." }
                      { value: "15", name: "port_spi10_spi_miso", desc: "Connect port spi_miso from port group spi10 to this pad." }
                      { value: "16", name: "port_spi10_spi_mosi", desc: "Connect port spi_mosi from port group spi10 to this pad." }
                      { value: "17", name: "port_spi10_spi_sck", desc: "Connect port spi_sck from port group spi10 to this pad." }
                      { value: "18", name: "port_uart2_uart_rx", desc: "Connect port uart_rx from port group uart2 to this pad." }
                      { value: "19", name: "port_uart2_uart_tx", desc: "Connect port uart_tx from port group uart2 to this pad." }
                      { value: "20", name: "port_uart3_uart_rx", desc: "Connect port uart_rx from port group uart3 to this pad." }
                      { value: "21", name: "port_uart3_uart_tx", desc: "Connect port uart_tx from port group uart3 to this pad." }
                  ]
              }
          ]
      }

      {
          name: PAD_IO_F_02_CFG
          desc: '''
            Pad signal configuration.
          '''
          swaccess: "rw"
          fields: [
            {
                bits: "0"
                name: chip2pad
                desc: '''
                     The signal that connects to the pads TX driver
                '''
                swaccess: "rw"
                hwaccess: "hro"
                resval: "0"
            },
            {
                bits: "1"
                name: oen
                desc: '''
                     Output enable signal, active low
                '''
                swaccess: "rw"
                hwaccess: "hro"
                resval: "1"
            },
          ]
      }

       {
          name: PAD_IO_F_02_MUX_SEL
          desc: '''
              Pad signal port multiplex selection for pad pad_io_f_02. The programmed value defines which port
              is connected to the pad.
          '''
          swaccess: "rw"
          hwaccess: "hro"
          resval: 0
          fields: [
              {
                  bits: "4:0"
                  enum: [
                      { value: "0", name: "register", desc: "Connects the Pad to the internal configuration register."}
                      { value: "1", name: "port_cam1_cam_data0_i", desc: "Connect port cam_data0_i from port group cam1 to this pad." }
                      { value: "2", name: "port_cam1_cam_data1_i", desc: "Connect port cam_data1_i from port group cam1 to this pad." }
                      { value: "3", name: "port_cam1_cam_data2_i", desc: "Connect port cam_data2_i from port group cam1 to this pad." }
                      { value: "4", name: "port_cam1_cam_data3_i", desc: "Connect port cam_data3_i from port group cam1 to this pad." }
                      { value: "5", name: "port_cam1_cam_data4_i", desc: "Connect port cam_data4_i from port group cam1 to this pad." }
                      { value: "6", name: "port_cam1_cam_data5_i", desc: "Connect port cam_data5_i from port group cam1 to this pad." }
                      { value: "7", name: "port_cam1_cam_data6_i", desc: "Connect port cam_data6_i from port group cam1 to this pad." }
                      { value: "8", name: "port_cam1_cam_data7_i", desc: "Connect port cam_data7_i from port group cam1 to this pad." }
                      { value: "9", name: "port_cam1_cam_hsync", desc: "Connect port cam_hsync from port group cam1 to this pad." }
                      { value: "10", name: "port_cam1_cam_pclk", desc: "Connect port cam_pclk from port group cam1 to this pad." }
                      { value: "11", name: "port_cam1_cam_vsync", desc: "Connect port cam_vsync from port group cam1 to this pad." }
                      { value: "12", name: "port_i2c4_i2c_scl", desc: "Connect port i2c_scl from port group i2c4 to this pad." }
                      { value: "13", name: "port_i2c4_i2c_sda", desc: "Connect port i2c_sda from port group i2c4 to this pad." }
                      { value: "14", name: "port_spi10_spi_cs", desc: "Connect port spi_cs from port group spi10 to this pad." }
                      { value: "15", name: "port_spi10_spi_miso", desc: "Connect port spi_miso from port group spi10 to this pad." }
                      { value: "16", name: "port_spi10_spi_mosi", desc: "Connect port spi_mosi from port group spi10 to this pad." }
                      { value: "17", name: "port_spi10_spi_sck", desc: "Connect port spi_sck from port group spi10 to this pad." }
                      { value: "18", name: "port_uart2_uart_rx", desc: "Connect port uart_rx from port group uart2 to this pad." }
                      { value: "19", name: "port_uart2_uart_tx", desc: "Connect port uart_tx from port group uart2 to this pad." }
                      { value: "20", name: "port_uart3_uart_rx", desc: "Connect port uart_rx from port group uart3 to this pad." }
                      { value: "21", name: "port_uart3_uart_tx", desc: "Connect port uart_tx from port group uart3 to this pad." }
                  ]
              }
          ]
      }

      {
          name: PAD_IO_F_03_CFG
          desc: '''
            Pad signal configuration.
          '''
          swaccess: "rw"
          fields: [
            {
                bits: "0"
                name: chip2pad
                desc: '''
                     The signal that connects to the pads TX driver
                '''
                swaccess: "rw"
                hwaccess: "hro"
                resval: "0"
            },
            {
                bits: "1"
                name: oen
                desc: '''
                     Output enable signal, active low
                '''
                swaccess: "rw"
                hwaccess: "hro"
                resval: "1"
            },
          ]
      }

       {
          name: PAD_IO_F_03_MUX_SEL
          desc: '''
              Pad signal port multiplex selection for pad pad_io_f_03. The programmed value defines which port
              is connected to the pad.
          '''
          swaccess: "rw"
          hwaccess: "hro"
          resval: 0
          fields: [
              {
                  bits: "4:0"
                  enum: [
                      { value: "0", name: "register", desc: "Connects the Pad to the internal configuration register."}
                      { value: "1", name: "port_cam1_cam_data0_i", desc: "Connect port cam_data0_i from port group cam1 to this pad." }
                      { value: "2", name: "port_cam1_cam_data1_i", desc: "Connect port cam_data1_i from port group cam1 to this pad." }
                      { value: "3", name: "port_cam1_cam_data2_i", desc: "Connect port cam_data2_i from port group cam1 to this pad." }
                      { value: "4", name: "port_cam1_cam_data3_i", desc: "Connect port cam_data3_i from port group cam1 to this pad." }
                      { value: "5", name: "port_cam1_cam_data4_i", desc: "Connect port cam_data4_i from port group cam1 to this pad." }
                      { value: "6", name: "port_cam1_cam_data5_i", desc: "Connect port cam_data5_i from port group cam1 to this pad." }
                      { value: "7", name: "port_cam1_cam_data6_i", desc: "Connect port cam_data6_i from port group cam1 to this pad." }
                      { value: "8", name: "port_cam1_cam_data7_i", desc: "Connect port cam_data7_i from port group cam1 to this pad." }
                      { value: "9", name: "port_cam1_cam_hsync", desc: "Connect port cam_hsync from port group cam1 to this pad." }
                      { value: "10", name: "port_cam1_cam_pclk", desc: "Connect port cam_pclk from port group cam1 to this pad." }
                      { value: "11", name: "port_cam1_cam_vsync", desc: "Connect port cam_vsync from port group cam1 to this pad." }
                      { value: "12", name: "port_i2c4_i2c_scl", desc: "Connect port i2c_scl from port group i2c4 to this pad." }
                      { value: "13", name: "port_i2c4_i2c_sda", desc: "Connect port i2c_sda from port group i2c4 to this pad." }
                      { value: "14", name: "port_spi10_spi_cs", desc: "Connect port spi_cs from port group spi10 to this pad." }
                      { value: "15", name: "port_spi10_spi_miso", desc: "Connect port spi_miso from port group spi10 to this pad." }
                      { value: "16", name: "port_spi10_spi_mosi", desc: "Connect port spi_mosi from port group spi10 to this pad." }
                      { value: "17", name: "port_spi10_spi_sck", desc: "Connect port spi_sck from port group spi10 to this pad." }
                      { value: "18", name: "port_uart2_uart_rx", desc: "Connect port uart_rx from port group uart2 to this pad." }
                      { value: "19", name: "port_uart2_uart_tx", desc: "Connect port uart_tx from port group uart2 to this pad." }
                      { value: "20", name: "port_uart3_uart_rx", desc: "Connect port uart_rx from port group uart3 to this pad." }
                      { value: "21", name: "port_uart3_uart_tx", desc: "Connect port uart_tx from port group uart3 to this pad." }
                  ]
              }
          ]
      }

      {
          name: PAD_IO_F_04_CFG
          desc: '''
            Pad signal configuration.
          '''
          swaccess: "rw"
          fields: [
            {
                bits: "0"
                name: chip2pad
                desc: '''
                     The signal that connects to the pads TX driver
                '''
                swaccess: "rw"
                hwaccess: "hro"
                resval: "0"
            },
            {
                bits: "1"
                name: oen
                desc: '''
                     Output enable signal, active low
                '''
                swaccess: "rw"
                hwaccess: "hro"
                resval: "1"
            },
          ]
      }

       {
          name: PAD_IO_F_04_MUX_SEL
          desc: '''
              Pad signal port multiplex selection for pad pad_io_f_04. The programmed value defines which port
              is connected to the pad.
          '''
          swaccess: "rw"
          hwaccess: "hro"
          resval: 0
          fields: [
              {
                  bits: "4:0"
                  enum: [
                      { value: "0", name: "register", desc: "Connects the Pad to the internal configuration register."}
                      { value: "1", name: "port_cam1_cam_data0_i", desc: "Connect port cam_data0_i from port group cam1 to this pad." }
                      { value: "2", name: "port_cam1_cam_data1_i", desc: "Connect port cam_data1_i from port group cam1 to this pad." }
                      { value: "3", name: "port_cam1_cam_data2_i", desc: "Connect port cam_data2_i from port group cam1 to this pad." }
                      { value: "4", name: "port_cam1_cam_data3_i", desc: "Connect port cam_data3_i from port group cam1 to this pad." }
                      { value: "5", name: "port_cam1_cam_data4_i", desc: "Connect port cam_data4_i from port group cam1 to this pad." }
                      { value: "6", name: "port_cam1_cam_data5_i", desc: "Connect port cam_data5_i from port group cam1 to this pad." }
                      { value: "7", name: "port_cam1_cam_data6_i", desc: "Connect port cam_data6_i from port group cam1 to this pad." }
                      { value: "8", name: "port_cam1_cam_data7_i", desc: "Connect port cam_data7_i from port group cam1 to this pad." }
                      { value: "9", name: "port_cam1_cam_hsync", desc: "Connect port cam_hsync from port group cam1 to this pad." }
                      { value: "10", name: "port_cam1_cam_pclk", desc: "Connect port cam_pclk from port group cam1 to this pad." }
                      { value: "11", name: "port_cam1_cam_vsync", desc: "Connect port cam_vsync from port group cam1 to this pad." }
                      { value: "12", name: "port_i2c4_i2c_scl", desc: "Connect port i2c_scl from port group i2c4 to this pad." }
                      { value: "13", name: "port_i2c4_i2c_sda", desc: "Connect port i2c_sda from port group i2c4 to this pad." }
                      { value: "14", name: "port_spi10_spi_cs", desc: "Connect port spi_cs from port group spi10 to this pad." }
                      { value: "15", name: "port_spi10_spi_miso", desc: "Connect port spi_miso from port group spi10 to this pad." }
                      { value: "16", name: "port_spi10_spi_mosi", desc: "Connect port spi_mosi from port group spi10 to this pad." }
                      { value: "17", name: "port_spi10_spi_sck", desc: "Connect port spi_sck from port group spi10 to this pad." }
                      { value: "18", name: "port_uart2_uart_rx", desc: "Connect port uart_rx from port group uart2 to this pad." }
                      { value: "19", name: "port_uart2_uart_tx", desc: "Connect port uart_tx from port group uart2 to this pad." }
                      { value: "20", name: "port_uart3_uart_rx", desc: "Connect port uart_rx from port group uart3 to this pad." }
                      { value: "21", name: "port_uart3_uart_tx", desc: "Connect port uart_tx from port group uart3 to this pad." }
                  ]
              }
          ]
      }

      {
          name: PAD_IO_F_05_CFG
          desc: '''
            Pad signal configuration.
          '''
          swaccess: "rw"
          fields: [
            {
                bits: "0"
                name: chip2pad
                desc: '''
                     The signal that connects to the pads TX driver
                '''
                swaccess: "rw"
                hwaccess: "hro"
                resval: "0"
            },
            {
                bits: "1"
                name: oen
                desc: '''
                     Output enable signal, active low
                '''
                swaccess: "rw"
                hwaccess: "hro"
                resval: "1"
            },
          ]
      }

       {
          name: PAD_IO_F_05_MUX_SEL
          desc: '''
              Pad signal port multiplex selection for pad pad_io_f_05. The programmed value defines which port
              is connected to the pad.
          '''
          swaccess: "rw"
          hwaccess: "hro"
          resval: 0
          fields: [
              {
                  bits: "4:0"
                  enum: [
                      { value: "0", name: "register", desc: "Connects the Pad to the internal configuration register."}
                      { value: "1", name: "port_cam1_cam_data0_i", desc: "Connect port cam_data0_i from port group cam1 to this pad." }
                      { value: "2", name: "port_cam1_cam_data1_i", desc: "Connect port cam_data1_i from port group cam1 to this pad." }
                      { value: "3", name: "port_cam1_cam_data2_i", desc: "Connect port cam_data2_i from port group cam1 to this pad." }
                      { value: "4", name: "port_cam1_cam_data3_i", desc: "Connect port cam_data3_i from port group cam1 to this pad." }
                      { value: "5", name: "port_cam1_cam_data4_i", desc: "Connect port cam_data4_i from port group cam1 to this pad." }
                      { value: "6", name: "port_cam1_cam_data5_i", desc: "Connect port cam_data5_i from port group cam1 to this pad." }
                      { value: "7", name: "port_cam1_cam_data6_i", desc: "Connect port cam_data6_i from port group cam1 to this pad." }
                      { value: "8", name: "port_cam1_cam_data7_i", desc: "Connect port cam_data7_i from port group cam1 to this pad." }
                      { value: "9", name: "port_cam1_cam_hsync", desc: "Connect port cam_hsync from port group cam1 to this pad." }
                      { value: "10", name: "port_cam1_cam_pclk", desc: "Connect port cam_pclk from port group cam1 to this pad." }
                      { value: "11", name: "port_cam1_cam_vsync", desc: "Connect port cam_vsync from port group cam1 to this pad." }
                      { value: "12", name: "port_i2c4_i2c_scl", desc: "Connect port i2c_scl from port group i2c4 to this pad." }
                      { value: "13", name: "port_i2c4_i2c_sda", desc: "Connect port i2c_sda from port group i2c4 to this pad." }
                      { value: "14", name: "port_spi10_spi_cs", desc: "Connect port spi_cs from port group spi10 to this pad." }
                      { value: "15", name: "port_spi10_spi_miso", desc: "Connect port spi_miso from port group spi10 to this pad." }
                      { value: "16", name: "port_spi10_spi_mosi", desc: "Connect port spi_mosi from port group spi10 to this pad." }
                      { value: "17", name: "port_spi10_spi_sck", desc: "Connect port spi_sck from port group spi10 to this pad." }
                      { value: "18", name: "port_uart2_uart_rx", desc: "Connect port uart_rx from port group uart2 to this pad." }
                      { value: "19", name: "port_uart2_uart_tx", desc: "Connect port uart_tx from port group uart2 to this pad." }
                      { value: "20", name: "port_uart3_uart_rx", desc: "Connect port uart_rx from port group uart3 to this pad." }
                      { value: "21", name: "port_uart3_uart_tx", desc: "Connect port uart_tx from port group uart3 to this pad." }
                  ]
              }
          ]
      }

      {
          name: PAD_IO_F_06_CFG
          desc: '''
            Pad signal configuration.
          '''
          swaccess: "rw"
          fields: [
            {
                bits: "0"
                name: chip2pad
                desc: '''
                     The signal that connects to the pads TX driver
                '''
                swaccess: "rw"
                hwaccess: "hro"
                resval: "0"
            },
            {
                bits: "1"
                name: oen
                desc: '''
                     Output enable signal, active low
                '''
                swaccess: "rw"
                hwaccess: "hro"
                resval: "1"
            },
          ]
      }

       {
          name: PAD_IO_F_06_MUX_SEL
          desc: '''
              Pad signal port multiplex selection for pad pad_io_f_06. The programmed value defines which port
              is connected to the pad.
          '''
          swaccess: "rw"
          hwaccess: "hro"
          resval: 0
          fields: [
              {
                  bits: "4:0"
                  enum: [
                      { value: "0", name: "register", desc: "Connects the Pad to the internal configuration register."}
                      { value: "1", name: "port_cam1_cam_data0_i", desc: "Connect port cam_data0_i from port group cam1 to this pad." }
                      { value: "2", name: "port_cam1_cam_data1_i", desc: "Connect port cam_data1_i from port group cam1 to this pad." }
                      { value: "3", name: "port_cam1_cam_data2_i", desc: "Connect port cam_data2_i from port group cam1 to this pad." }
                      { value: "4", name: "port_cam1_cam_data3_i", desc: "Connect port cam_data3_i from port group cam1 to this pad." }
                      { value: "5", name: "port_cam1_cam_data4_i", desc: "Connect port cam_data4_i from port group cam1 to this pad." }
                      { value: "6", name: "port_cam1_cam_data5_i", desc: "Connect port cam_data5_i from port group cam1 to this pad." }
                      { value: "7", name: "port_cam1_cam_data6_i", desc: "Connect port cam_data6_i from port group cam1 to this pad." }
                      { value: "8", name: "port_cam1_cam_data7_i", desc: "Connect port cam_data7_i from port group cam1 to this pad." }
                      { value: "9", name: "port_cam1_cam_hsync", desc: "Connect port cam_hsync from port group cam1 to this pad." }
                      { value: "10", name: "port_cam1_cam_pclk", desc: "Connect port cam_pclk from port group cam1 to this pad." }
                      { value: "11", name: "port_cam1_cam_vsync", desc: "Connect port cam_vsync from port group cam1 to this pad." }
                      { value: "12", name: "port_i2c4_i2c_scl", desc: "Connect port i2c_scl from port group i2c4 to this pad." }
                      { value: "13", name: "port_i2c4_i2c_sda", desc: "Connect port i2c_sda from port group i2c4 to this pad." }
                      { value: "14", name: "port_spi10_spi_cs", desc: "Connect port spi_cs from port group spi10 to this pad." }
                      { value: "15", name: "port_spi10_spi_miso", desc: "Connect port spi_miso from port group spi10 to this pad." }
                      { value: "16", name: "port_spi10_spi_mosi", desc: "Connect port spi_mosi from port group spi10 to this pad." }
                      { value: "17", name: "port_spi10_spi_sck", desc: "Connect port spi_sck from port group spi10 to this pad." }
                      { value: "18", name: "port_uart2_uart_rx", desc: "Connect port uart_rx from port group uart2 to this pad." }
                      { value: "19", name: "port_uart2_uart_tx", desc: "Connect port uart_tx from port group uart2 to this pad." }
                      { value: "20", name: "port_uart3_uart_rx", desc: "Connect port uart_rx from port group uart3 to this pad." }
                      { value: "21", name: "port_uart3_uart_tx", desc: "Connect port uart_tx from port group uart3 to this pad." }
                  ]
              }
          ]
      }

      {
          name: PAD_IO_F_07_CFG
          desc: '''
            Pad signal configuration.
          '''
          swaccess: "rw"
          fields: [
            {
                bits: "0"
                name: chip2pad
                desc: '''
                     The signal that connects to the pads TX driver
                '''
                swaccess: "rw"
                hwaccess: "hro"
                resval: "0"
            },
            {
                bits: "1"
                name: oen
                desc: '''
                     Output enable signal, active low
                '''
                swaccess: "rw"
                hwaccess: "hro"
                resval: "1"
            },
          ]
      }

       {
          name: PAD_IO_F_07_MUX_SEL
          desc: '''
              Pad signal port multiplex selection for pad pad_io_f_07. The programmed value defines which port
              is connected to the pad.
          '''
          swaccess: "rw"
          hwaccess: "hro"
          resval: 0
          fields: [
              {
                  bits: "4:0"
                  enum: [
                      { value: "0", name: "register", desc: "Connects the Pad to the internal configuration register."}
                      { value: "1", name: "port_cam1_cam_data0_i", desc: "Connect port cam_data0_i from port group cam1 to this pad." }
                      { value: "2", name: "port_cam1_cam_data1_i", desc: "Connect port cam_data1_i from port group cam1 to this pad." }
                      { value: "3", name: "port_cam1_cam_data2_i", desc: "Connect port cam_data2_i from port group cam1 to this pad." }
                      { value: "4", name: "port_cam1_cam_data3_i", desc: "Connect port cam_data3_i from port group cam1 to this pad." }
                      { value: "5", name: "port_cam1_cam_data4_i", desc: "Connect port cam_data4_i from port group cam1 to this pad." }
                      { value: "6", name: "port_cam1_cam_data5_i", desc: "Connect port cam_data5_i from port group cam1 to this pad." }
                      { value: "7", name: "port_cam1_cam_data6_i", desc: "Connect port cam_data6_i from port group cam1 to this pad." }
                      { value: "8", name: "port_cam1_cam_data7_i", desc: "Connect port cam_data7_i from port group cam1 to this pad." }
                      { value: "9", name: "port_cam1_cam_hsync", desc: "Connect port cam_hsync from port group cam1 to this pad." }
                      { value: "10", name: "port_cam1_cam_pclk", desc: "Connect port cam_pclk from port group cam1 to this pad." }
                      { value: "11", name: "port_cam1_cam_vsync", desc: "Connect port cam_vsync from port group cam1 to this pad." }
                      { value: "12", name: "port_i2c4_i2c_scl", desc: "Connect port i2c_scl from port group i2c4 to this pad." }
                      { value: "13", name: "port_i2c4_i2c_sda", desc: "Connect port i2c_sda from port group i2c4 to this pad." }
                      { value: "14", name: "port_spi10_spi_cs", desc: "Connect port spi_cs from port group spi10 to this pad." }
                      { value: "15", name: "port_spi10_spi_miso", desc: "Connect port spi_miso from port group spi10 to this pad." }
                      { value: "16", name: "port_spi10_spi_mosi", desc: "Connect port spi_mosi from port group spi10 to this pad." }
                      { value: "17", name: "port_spi10_spi_sck", desc: "Connect port spi_sck from port group spi10 to this pad." }
                      { value: "18", name: "port_uart2_uart_rx", desc: "Connect port uart_rx from port group uart2 to this pad." }
                      { value: "19", name: "port_uart2_uart_tx", desc: "Connect port uart_tx from port group uart2 to this pad." }
                      { value: "20", name: "port_uart3_uart_rx", desc: "Connect port uart_rx from port group uart3 to this pad." }
                      { value: "21", name: "port_uart3_uart_tx", desc: "Connect port uart_tx from port group uart3 to this pad." }
                  ]
              }
          ]
      }

      {
          name: PAD_IO_F_08_CFG
          desc: '''
            Pad signal configuration.
          '''
          swaccess: "rw"
          fields: [
            {
                bits: "0"
                name: chip2pad
                desc: '''
                     The signal that connects to the pads TX driver
                '''
                swaccess: "rw"
                hwaccess: "hro"
                resval: "0"
            },
            {
                bits: "1"
                name: oen
                desc: '''
                     Output enable signal, active low
                '''
                swaccess: "rw"
                hwaccess: "hro"
                resval: "1"
            },
          ]
      }

       {
          name: PAD_IO_F_08_MUX_SEL
          desc: '''
              Pad signal port multiplex selection for pad pad_io_f_08. The programmed value defines which port
              is connected to the pad.
          '''
          swaccess: "rw"
          hwaccess: "hro"
          resval: 0
          fields: [
              {
                  bits: "4:0"
                  enum: [
                      { value: "0", name: "register", desc: "Connects the Pad to the internal configuration register."}
                      { value: "1", name: "port_cam1_cam_data0_i", desc: "Connect port cam_data0_i from port group cam1 to this pad." }
                      { value: "2", name: "port_cam1_cam_data1_i", desc: "Connect port cam_data1_i from port group cam1 to this pad." }
                      { value: "3", name: "port_cam1_cam_data2_i", desc: "Connect port cam_data2_i from port group cam1 to this pad." }
                      { value: "4", name: "port_cam1_cam_data3_i", desc: "Connect port cam_data3_i from port group cam1 to this pad." }
                      { value: "5", name: "port_cam1_cam_data4_i", desc: "Connect port cam_data4_i from port group cam1 to this pad." }
                      { value: "6", name: "port_cam1_cam_data5_i", desc: "Connect port cam_data5_i from port group cam1 to this pad." }
                      { value: "7", name: "port_cam1_cam_data6_i", desc: "Connect port cam_data6_i from port group cam1 to this pad." }
                      { value: "8", name: "port_cam1_cam_data7_i", desc: "Connect port cam_data7_i from port group cam1 to this pad." }
                      { value: "9", name: "port_cam1_cam_hsync", desc: "Connect port cam_hsync from port group cam1 to this pad." }
                      { value: "10", name: "port_cam1_cam_pclk", desc: "Connect port cam_pclk from port group cam1 to this pad." }
                      { value: "11", name: "port_cam1_cam_vsync", desc: "Connect port cam_vsync from port group cam1 to this pad." }
                      { value: "12", name: "port_i2c4_i2c_scl", desc: "Connect port i2c_scl from port group i2c4 to this pad." }
                      { value: "13", name: "port_i2c4_i2c_sda", desc: "Connect port i2c_sda from port group i2c4 to this pad." }
                      { value: "14", name: "port_spi10_spi_cs", desc: "Connect port spi_cs from port group spi10 to this pad." }
                      { value: "15", name: "port_spi10_spi_miso", desc: "Connect port spi_miso from port group spi10 to this pad." }
                      { value: "16", name: "port_spi10_spi_mosi", desc: "Connect port spi_mosi from port group spi10 to this pad." }
                      { value: "17", name: "port_spi10_spi_sck", desc: "Connect port spi_sck from port group spi10 to this pad." }
                      { value: "18", name: "port_uart2_uart_rx", desc: "Connect port uart_rx from port group uart2 to this pad." }
                      { value: "19", name: "port_uart2_uart_tx", desc: "Connect port uart_tx from port group uart2 to this pad." }
                      { value: "20", name: "port_uart3_uart_rx", desc: "Connect port uart_rx from port group uart3 to this pad." }
                      { value: "21", name: "port_uart3_uart_tx", desc: "Connect port uart_tx from port group uart3 to this pad." }
                  ]
              }
          ]
      }

      {
          name: PAD_IO_F_09_CFG
          desc: '''
            Pad signal configuration.
          '''
          swaccess: "rw"
          fields: [
            {
                bits: "0"
                name: chip2pad
                desc: '''
                     The signal that connects to the pads TX driver
                '''
                swaccess: "rw"
                hwaccess: "hro"
                resval: "0"
            },
            {
                bits: "1"
                name: oen
                desc: '''
                     Output enable signal, active low
                '''
                swaccess: "rw"
                hwaccess: "hro"
                resval: "1"
            },
          ]
      }

       {
          name: PAD_IO_F_09_MUX_SEL
          desc: '''
              Pad signal port multiplex selection for pad pad_io_f_09. The programmed value defines which port
              is connected to the pad.
          '''
          swaccess: "rw"
          hwaccess: "hro"
          resval: 0
          fields: [
              {
                  bits: "4:0"
                  enum: [
                      { value: "0", name: "register", desc: "Connects the Pad to the internal configuration register."}
                      { value: "1", name: "port_cam1_cam_data0_i", desc: "Connect port cam_data0_i from port group cam1 to this pad." }
                      { value: "2", name: "port_cam1_cam_data1_i", desc: "Connect port cam_data1_i from port group cam1 to this pad." }
                      { value: "3", name: "port_cam1_cam_data2_i", desc: "Connect port cam_data2_i from port group cam1 to this pad." }
                      { value: "4", name: "port_cam1_cam_data3_i", desc: "Connect port cam_data3_i from port group cam1 to this pad." }
                      { value: "5", name: "port_cam1_cam_data4_i", desc: "Connect port cam_data4_i from port group cam1 to this pad." }
                      { value: "6", name: "port_cam1_cam_data5_i", desc: "Connect port cam_data5_i from port group cam1 to this pad." }
                      { value: "7", name: "port_cam1_cam_data6_i", desc: "Connect port cam_data6_i from port group cam1 to this pad." }
                      { value: "8", name: "port_cam1_cam_data7_i", desc: "Connect port cam_data7_i from port group cam1 to this pad." }
                      { value: "9", name: "port_cam1_cam_hsync", desc: "Connect port cam_hsync from port group cam1 to this pad." }
                      { value: "10", name: "port_cam1_cam_pclk", desc: "Connect port cam_pclk from port group cam1 to this pad." }
                      { value: "11", name: "port_cam1_cam_vsync", desc: "Connect port cam_vsync from port group cam1 to this pad." }
                      { value: "12", name: "port_i2c4_i2c_scl", desc: "Connect port i2c_scl from port group i2c4 to this pad." }
                      { value: "13", name: "port_i2c4_i2c_sda", desc: "Connect port i2c_sda from port group i2c4 to this pad." }
                      { value: "14", name: "port_spi10_spi_cs", desc: "Connect port spi_cs from port group spi10 to this pad." }
                      { value: "15", name: "port_spi10_spi_miso", desc: "Connect port spi_miso from port group spi10 to this pad." }
                      { value: "16", name: "port_spi10_spi_mosi", desc: "Connect port spi_mosi from port group spi10 to this pad." }
                      { value: "17", name: "port_spi10_spi_sck", desc: "Connect port spi_sck from port group spi10 to this pad." }
                      { value: "18", name: "port_uart2_uart_rx", desc: "Connect port uart_rx from port group uart2 to this pad." }
                      { value: "19", name: "port_uart2_uart_tx", desc: "Connect port uart_tx from port group uart2 to this pad." }
                      { value: "20", name: "port_uart3_uart_rx", desc: "Connect port uart_rx from port group uart3 to this pad." }
                      { value: "21", name: "port_uart3_uart_tx", desc: "Connect port uart_tx from port group uart3 to this pad." }
                  ]
              }
          ]
      }

      {
          name: PAD_IO_F_10_CFG
          desc: '''
            Pad signal configuration.
          '''
          swaccess: "rw"
          fields: [
            {
                bits: "0"
                name: chip2pad
                desc: '''
                     The signal that connects to the pads TX driver
                '''
                swaccess: "rw"
                hwaccess: "hro"
                resval: "0"
            },
            {
                bits: "1"
                name: oen
                desc: '''
                     Output enable signal, active low
                '''
                swaccess: "rw"
                hwaccess: "hro"
                resval: "1"
            },
          ]
      }

       {
          name: PAD_IO_F_10_MUX_SEL
          desc: '''
              Pad signal port multiplex selection for pad pad_io_f_10. The programmed value defines which port
              is connected to the pad.
          '''
          swaccess: "rw"
          hwaccess: "hro"
          resval: 0
          fields: [
              {
                  bits: "4:0"
                  enum: [
                      { value: "0", name: "register", desc: "Connects the Pad to the internal configuration register."}
                      { value: "1", name: "port_cam1_cam_data0_i", desc: "Connect port cam_data0_i from port group cam1 to this pad." }
                      { value: "2", name: "port_cam1_cam_data1_i", desc: "Connect port cam_data1_i from port group cam1 to this pad." }
                      { value: "3", name: "port_cam1_cam_data2_i", desc: "Connect port cam_data2_i from port group cam1 to this pad." }
                      { value: "4", name: "port_cam1_cam_data3_i", desc: "Connect port cam_data3_i from port group cam1 to this pad." }
                      { value: "5", name: "port_cam1_cam_data4_i", desc: "Connect port cam_data4_i from port group cam1 to this pad." }
                      { value: "6", name: "port_cam1_cam_data5_i", desc: "Connect port cam_data5_i from port group cam1 to this pad." }
                      { value: "7", name: "port_cam1_cam_data6_i", desc: "Connect port cam_data6_i from port group cam1 to this pad." }
                      { value: "8", name: "port_cam1_cam_data7_i", desc: "Connect port cam_data7_i from port group cam1 to this pad." }
                      { value: "9", name: "port_cam1_cam_hsync", desc: "Connect port cam_hsync from port group cam1 to this pad." }
                      { value: "10", name: "port_cam1_cam_pclk", desc: "Connect port cam_pclk from port group cam1 to this pad." }
                      { value: "11", name: "port_cam1_cam_vsync", desc: "Connect port cam_vsync from port group cam1 to this pad." }
                      { value: "12", name: "port_i2c4_i2c_scl", desc: "Connect port i2c_scl from port group i2c4 to this pad." }
                      { value: "13", name: "port_i2c4_i2c_sda", desc: "Connect port i2c_sda from port group i2c4 to this pad." }
                      { value: "14", name: "port_spi10_spi_cs", desc: "Connect port spi_cs from port group spi10 to this pad." }
                      { value: "15", name: "port_spi10_spi_miso", desc: "Connect port spi_miso from port group spi10 to this pad." }
                      { value: "16", name: "port_spi10_spi_mosi", desc: "Connect port spi_mosi from port group spi10 to this pad." }
                      { value: "17", name: "port_spi10_spi_sck", desc: "Connect port spi_sck from port group spi10 to this pad." }
                      { value: "18", name: "port_uart2_uart_rx", desc: "Connect port uart_rx from port group uart2 to this pad." }
                      { value: "19", name: "port_uart2_uart_tx", desc: "Connect port uart_tx from port group uart2 to this pad." }
                      { value: "20", name: "port_uart3_uart_rx", desc: "Connect port uart_rx from port group uart3 to this pad." }
                      { value: "21", name: "port_uart3_uart_tx", desc: "Connect port uart_tx from port group uart3 to this pad." }
                  ]
              }
          ]
      }

      {
          name: PAD_IO_G_00_CFG
          desc: '''
            Pad signal configuration.
          '''
          swaccess: "rw"
          fields: [
            {
                bits: "0"
                name: chip2pad
                desc: '''
                     The signal that connects to the pads TX driver
                '''
                swaccess: "rw"
                hwaccess: "hro"
                resval: "0"
            },
            {
                bits: "1"
                name: oen
                desc: '''
                     Output enable signal, active low
                '''
                swaccess: "rw"
                hwaccess: "hro"
                resval: "1"
            },
          ]
      }

       {
          name: PAD_IO_G_00_MUX_SEL
          desc: '''
              Pad signal port multiplex selection for pad pad_io_g_00. The programmed value defines which port
              is connected to the pad.
          '''
          swaccess: "rw"
          hwaccess: "hro"
          resval: 0
          fields: [
              {
                  bits: "4:0"
                  enum: [
                      { value: "0", name: "register", desc: "Connects the Pad to the internal configuration register."}
                      { value: "1", name: "port_eth0_eth_rst", desc: "Connect port eth_rst from port group eth0 to this pad." }
                      { value: "2", name: "port_eth0_eth_rxck", desc: "Connect port eth_rxck from port group eth0 to this pad." }
                      { value: "3", name: "port_eth0_eth_rxctl", desc: "Connect port eth_rxctl from port group eth0 to this pad." }
                      { value: "4", name: "port_eth0_eth_rxd0", desc: "Connect port eth_rxd0 from port group eth0 to this pad." }
                      { value: "5", name: "port_eth0_eth_rxd1", desc: "Connect port eth_rxd1 from port group eth0 to this pad." }
                      { value: "6", name: "port_eth0_eth_rxd2", desc: "Connect port eth_rxd2 from port group eth0 to this pad." }
                      { value: "7", name: "port_eth0_eth_rxd3", desc: "Connect port eth_rxd3 from port group eth0 to this pad." }
                      { value: "8", name: "port_eth0_eth_txck", desc: "Connect port eth_txck from port group eth0 to this pad." }
                      { value: "9", name: "port_eth0_eth_txctl", desc: "Connect port eth_txctl from port group eth0 to this pad." }
                      { value: "10", name: "port_eth0_eth_txd0", desc: "Connect port eth_txd0 from port group eth0 to this pad." }
                      { value: "11", name: "port_eth0_eth_txd1", desc: "Connect port eth_txd1 from port group eth0 to this pad." }
                      { value: "12", name: "port_eth0_eth_txd2", desc: "Connect port eth_txd2 from port group eth0 to this pad." }
                      { value: "13", name: "port_eth0_eth_txd3", desc: "Connect port eth_txd3 from port group eth0 to this pad." }
                      { value: "14", name: "port_sdio1_sdio_clk", desc: "Connect port sdio_clk from port group sdio1 to this pad." }
                      { value: "15", name: "port_sdio1_sdio_cmd", desc: "Connect port sdio_cmd from port group sdio1 to this pad." }
                      { value: "16", name: "port_sdio1_sdio_data0", desc: "Connect port sdio_data0 from port group sdio1 to this pad." }
                      { value: "17", name: "port_sdio1_sdio_data1", desc: "Connect port sdio_data1 from port group sdio1 to this pad." }
                      { value: "18", name: "port_sdio1_sdio_data2", desc: "Connect port sdio_data2 from port group sdio1 to this pad." }
                      { value: "19", name: "port_sdio1_sdio_data3", desc: "Connect port sdio_data3 from port group sdio1 to this pad." }
                      { value: "20", name: "port_uart_cf3_uart_cts", desc: "Connect port uart_cts from port group uart_cf3 to this pad." }
                      { value: "21", name: "port_uart_cf3_uart_rts", desc: "Connect port uart_rts from port group uart_cf3 to this pad." }
                      { value: "22", name: "port_uart_cf3_uart_rx", desc: "Connect port uart_rx from port group uart_cf3 to this pad." }
                      { value: "23", name: "port_uart_cf3_uart_tx", desc: "Connect port uart_tx from port group uart_cf3 to this pad." }
                  ]
              }
          ]
      }

      {
          name: PAD_IO_G_01_CFG
          desc: '''
            Pad signal configuration.
          '''
          swaccess: "rw"
          fields: [
            {
                bits: "0"
                name: chip2pad
                desc: '''
                     The signal that connects to the pads TX driver
                '''
                swaccess: "rw"
                hwaccess: "hro"
                resval: "0"
            },
            {
                bits: "1"
                name: oen
                desc: '''
                     Output enable signal, active low
                '''
                swaccess: "rw"
                hwaccess: "hro"
                resval: "1"
            },
          ]
      }

       {
          name: PAD_IO_G_01_MUX_SEL
          desc: '''
              Pad signal port multiplex selection for pad pad_io_g_01. The programmed value defines which port
              is connected to the pad.
          '''
          swaccess: "rw"
          hwaccess: "hro"
          resval: 0
          fields: [
              {
                  bits: "4:0"
                  enum: [
                      { value: "0", name: "register", desc: "Connects the Pad to the internal configuration register."}
                      { value: "1", name: "port_eth0_eth_rst", desc: "Connect port eth_rst from port group eth0 to this pad." }
                      { value: "2", name: "port_eth0_eth_rxck", desc: "Connect port eth_rxck from port group eth0 to this pad." }
                      { value: "3", name: "port_eth0_eth_rxctl", desc: "Connect port eth_rxctl from port group eth0 to this pad." }
                      { value: "4", name: "port_eth0_eth_rxd0", desc: "Connect port eth_rxd0 from port group eth0 to this pad." }
                      { value: "5", name: "port_eth0_eth_rxd1", desc: "Connect port eth_rxd1 from port group eth0 to this pad." }
                      { value: "6", name: "port_eth0_eth_rxd2", desc: "Connect port eth_rxd2 from port group eth0 to this pad." }
                      { value: "7", name: "port_eth0_eth_rxd3", desc: "Connect port eth_rxd3 from port group eth0 to this pad." }
                      { value: "8", name: "port_eth0_eth_txck", desc: "Connect port eth_txck from port group eth0 to this pad." }
                      { value: "9", name: "port_eth0_eth_txctl", desc: "Connect port eth_txctl from port group eth0 to this pad." }
                      { value: "10", name: "port_eth0_eth_txd0", desc: "Connect port eth_txd0 from port group eth0 to this pad." }
                      { value: "11", name: "port_eth0_eth_txd1", desc: "Connect port eth_txd1 from port group eth0 to this pad." }
                      { value: "12", name: "port_eth0_eth_txd2", desc: "Connect port eth_txd2 from port group eth0 to this pad." }
                      { value: "13", name: "port_eth0_eth_txd3", desc: "Connect port eth_txd3 from port group eth0 to this pad." }
                      { value: "14", name: "port_sdio1_sdio_clk", desc: "Connect port sdio_clk from port group sdio1 to this pad." }
                      { value: "15", name: "port_sdio1_sdio_cmd", desc: "Connect port sdio_cmd from port group sdio1 to this pad." }
                      { value: "16", name: "port_sdio1_sdio_data0", desc: "Connect port sdio_data0 from port group sdio1 to this pad." }
                      { value: "17", name: "port_sdio1_sdio_data1", desc: "Connect port sdio_data1 from port group sdio1 to this pad." }
                      { value: "18", name: "port_sdio1_sdio_data2", desc: "Connect port sdio_data2 from port group sdio1 to this pad." }
                      { value: "19", name: "port_sdio1_sdio_data3", desc: "Connect port sdio_data3 from port group sdio1 to this pad." }
                      { value: "20", name: "port_uart_cf3_uart_cts", desc: "Connect port uart_cts from port group uart_cf3 to this pad." }
                      { value: "21", name: "port_uart_cf3_uart_rts", desc: "Connect port uart_rts from port group uart_cf3 to this pad." }
                      { value: "22", name: "port_uart_cf3_uart_rx", desc: "Connect port uart_rx from port group uart_cf3 to this pad." }
                      { value: "23", name: "port_uart_cf3_uart_tx", desc: "Connect port uart_tx from port group uart_cf3 to this pad." }
                  ]
              }
          ]
      }

      {
          name: PAD_IO_G_02_CFG
          desc: '''
            Pad signal configuration.
          '''
          swaccess: "rw"
          fields: [
            {
                bits: "0"
                name: chip2pad
                desc: '''
                     The signal that connects to the pads TX driver
                '''
                swaccess: "rw"
                hwaccess: "hro"
                resval: "0"
            },
            {
                bits: "1"
                name: oen
                desc: '''
                     Output enable signal, active low
                '''
                swaccess: "rw"
                hwaccess: "hro"
                resval: "1"
            },
          ]
      }

       {
          name: PAD_IO_G_02_MUX_SEL
          desc: '''
              Pad signal port multiplex selection for pad pad_io_g_02. The programmed value defines which port
              is connected to the pad.
          '''
          swaccess: "rw"
          hwaccess: "hro"
          resval: 0
          fields: [
              {
                  bits: "4:0"
                  enum: [
                      { value: "0", name: "register", desc: "Connects the Pad to the internal configuration register."}
                      { value: "1", name: "port_eth0_eth_rst", desc: "Connect port eth_rst from port group eth0 to this pad." }
                      { value: "2", name: "port_eth0_eth_rxck", desc: "Connect port eth_rxck from port group eth0 to this pad." }
                      { value: "3", name: "port_eth0_eth_rxctl", desc: "Connect port eth_rxctl from port group eth0 to this pad." }
                      { value: "4", name: "port_eth0_eth_rxd0", desc: "Connect port eth_rxd0 from port group eth0 to this pad." }
                      { value: "5", name: "port_eth0_eth_rxd1", desc: "Connect port eth_rxd1 from port group eth0 to this pad." }
                      { value: "6", name: "port_eth0_eth_rxd2", desc: "Connect port eth_rxd2 from port group eth0 to this pad." }
                      { value: "7", name: "port_eth0_eth_rxd3", desc: "Connect port eth_rxd3 from port group eth0 to this pad." }
                      { value: "8", name: "port_eth0_eth_txck", desc: "Connect port eth_txck from port group eth0 to this pad." }
                      { value: "9", name: "port_eth0_eth_txctl", desc: "Connect port eth_txctl from port group eth0 to this pad." }
                      { value: "10", name: "port_eth0_eth_txd0", desc: "Connect port eth_txd0 from port group eth0 to this pad." }
                      { value: "11", name: "port_eth0_eth_txd1", desc: "Connect port eth_txd1 from port group eth0 to this pad." }
                      { value: "12", name: "port_eth0_eth_txd2", desc: "Connect port eth_txd2 from port group eth0 to this pad." }
                      { value: "13", name: "port_eth0_eth_txd3", desc: "Connect port eth_txd3 from port group eth0 to this pad." }
                      { value: "14", name: "port_sdio1_sdio_clk", desc: "Connect port sdio_clk from port group sdio1 to this pad." }
                      { value: "15", name: "port_sdio1_sdio_cmd", desc: "Connect port sdio_cmd from port group sdio1 to this pad." }
                      { value: "16", name: "port_sdio1_sdio_data0", desc: "Connect port sdio_data0 from port group sdio1 to this pad." }
                      { value: "17", name: "port_sdio1_sdio_data1", desc: "Connect port sdio_data1 from port group sdio1 to this pad." }
                      { value: "18", name: "port_sdio1_sdio_data2", desc: "Connect port sdio_data2 from port group sdio1 to this pad." }
                      { value: "19", name: "port_sdio1_sdio_data3", desc: "Connect port sdio_data3 from port group sdio1 to this pad." }
                      { value: "20", name: "port_uart_cf3_uart_cts", desc: "Connect port uart_cts from port group uart_cf3 to this pad." }
                      { value: "21", name: "port_uart_cf3_uart_rts", desc: "Connect port uart_rts from port group uart_cf3 to this pad." }
                      { value: "22", name: "port_uart_cf3_uart_rx", desc: "Connect port uart_rx from port group uart_cf3 to this pad." }
                      { value: "23", name: "port_uart_cf3_uart_tx", desc: "Connect port uart_tx from port group uart_cf3 to this pad." }
                  ]
              }
          ]
      }

      {
          name: PAD_IO_G_03_CFG
          desc: '''
            Pad signal configuration.
          '''
          swaccess: "rw"
          fields: [
            {
                bits: "0"
                name: chip2pad
                desc: '''
                     The signal that connects to the pads TX driver
                '''
                swaccess: "rw"
                hwaccess: "hro"
                resval: "0"
            },
            {
                bits: "1"
                name: oen
                desc: '''
                     Output enable signal, active low
                '''
                swaccess: "rw"
                hwaccess: "hro"
                resval: "1"
            },
          ]
      }

       {
          name: PAD_IO_G_03_MUX_SEL
          desc: '''
              Pad signal port multiplex selection for pad pad_io_g_03. The programmed value defines which port
              is connected to the pad.
          '''
          swaccess: "rw"
          hwaccess: "hro"
          resval: 0
          fields: [
              {
                  bits: "4:0"
                  enum: [
                      { value: "0", name: "register", desc: "Connects the Pad to the internal configuration register."}
                      { value: "1", name: "port_eth0_eth_rst", desc: "Connect port eth_rst from port group eth0 to this pad." }
                      { value: "2", name: "port_eth0_eth_rxck", desc: "Connect port eth_rxck from port group eth0 to this pad." }
                      { value: "3", name: "port_eth0_eth_rxctl", desc: "Connect port eth_rxctl from port group eth0 to this pad." }
                      { value: "4", name: "port_eth0_eth_rxd0", desc: "Connect port eth_rxd0 from port group eth0 to this pad." }
                      { value: "5", name: "port_eth0_eth_rxd1", desc: "Connect port eth_rxd1 from port group eth0 to this pad." }
                      { value: "6", name: "port_eth0_eth_rxd2", desc: "Connect port eth_rxd2 from port group eth0 to this pad." }
                      { value: "7", name: "port_eth0_eth_rxd3", desc: "Connect port eth_rxd3 from port group eth0 to this pad." }
                      { value: "8", name: "port_eth0_eth_txck", desc: "Connect port eth_txck from port group eth0 to this pad." }
                      { value: "9", name: "port_eth0_eth_txctl", desc: "Connect port eth_txctl from port group eth0 to this pad." }
                      { value: "10", name: "port_eth0_eth_txd0", desc: "Connect port eth_txd0 from port group eth0 to this pad." }
                      { value: "11", name: "port_eth0_eth_txd1", desc: "Connect port eth_txd1 from port group eth0 to this pad." }
                      { value: "12", name: "port_eth0_eth_txd2", desc: "Connect port eth_txd2 from port group eth0 to this pad." }
                      { value: "13", name: "port_eth0_eth_txd3", desc: "Connect port eth_txd3 from port group eth0 to this pad." }
                      { value: "14", name: "port_sdio1_sdio_clk", desc: "Connect port sdio_clk from port group sdio1 to this pad." }
                      { value: "15", name: "port_sdio1_sdio_cmd", desc: "Connect port sdio_cmd from port group sdio1 to this pad." }
                      { value: "16", name: "port_sdio1_sdio_data0", desc: "Connect port sdio_data0 from port group sdio1 to this pad." }
                      { value: "17", name: "port_sdio1_sdio_data1", desc: "Connect port sdio_data1 from port group sdio1 to this pad." }
                      { value: "18", name: "port_sdio1_sdio_data2", desc: "Connect port sdio_data2 from port group sdio1 to this pad." }
                      { value: "19", name: "port_sdio1_sdio_data3", desc: "Connect port sdio_data3 from port group sdio1 to this pad." }
                      { value: "20", name: "port_uart_cf3_uart_cts", desc: "Connect port uart_cts from port group uart_cf3 to this pad." }
                      { value: "21", name: "port_uart_cf3_uart_rts", desc: "Connect port uart_rts from port group uart_cf3 to this pad." }
                      { value: "22", name: "port_uart_cf3_uart_rx", desc: "Connect port uart_rx from port group uart_cf3 to this pad." }
                      { value: "23", name: "port_uart_cf3_uart_tx", desc: "Connect port uart_tx from port group uart_cf3 to this pad." }
                  ]
              }
          ]
      }

      {
          name: PAD_IO_G_04_CFG
          desc: '''
            Pad signal configuration.
          '''
          swaccess: "rw"
          fields: [
            {
                bits: "0"
                name: chip2pad
                desc: '''
                     The signal that connects to the pads TX driver
                '''
                swaccess: "rw"
                hwaccess: "hro"
                resval: "0"
            },
            {
                bits: "1"
                name: oen
                desc: '''
                     Output enable signal, active low
                '''
                swaccess: "rw"
                hwaccess: "hro"
                resval: "1"
            },
          ]
      }

       {
          name: PAD_IO_G_04_MUX_SEL
          desc: '''
              Pad signal port multiplex selection for pad pad_io_g_04. The programmed value defines which port
              is connected to the pad.
          '''
          swaccess: "rw"
          hwaccess: "hro"
          resval: 0
          fields: [
              {
                  bits: "4:0"
                  enum: [
                      { value: "0", name: "register", desc: "Connects the Pad to the internal configuration register."}
                      { value: "1", name: "port_eth0_eth_rst", desc: "Connect port eth_rst from port group eth0 to this pad." }
                      { value: "2", name: "port_eth0_eth_rxck", desc: "Connect port eth_rxck from port group eth0 to this pad." }
                      { value: "3", name: "port_eth0_eth_rxctl", desc: "Connect port eth_rxctl from port group eth0 to this pad." }
                      { value: "4", name: "port_eth0_eth_rxd0", desc: "Connect port eth_rxd0 from port group eth0 to this pad." }
                      { value: "5", name: "port_eth0_eth_rxd1", desc: "Connect port eth_rxd1 from port group eth0 to this pad." }
                      { value: "6", name: "port_eth0_eth_rxd2", desc: "Connect port eth_rxd2 from port group eth0 to this pad." }
                      { value: "7", name: "port_eth0_eth_rxd3", desc: "Connect port eth_rxd3 from port group eth0 to this pad." }
                      { value: "8", name: "port_eth0_eth_txck", desc: "Connect port eth_txck from port group eth0 to this pad." }
                      { value: "9", name: "port_eth0_eth_txctl", desc: "Connect port eth_txctl from port group eth0 to this pad." }
                      { value: "10", name: "port_eth0_eth_txd0", desc: "Connect port eth_txd0 from port group eth0 to this pad." }
                      { value: "11", name: "port_eth0_eth_txd1", desc: "Connect port eth_txd1 from port group eth0 to this pad." }
                      { value: "12", name: "port_eth0_eth_txd2", desc: "Connect port eth_txd2 from port group eth0 to this pad." }
                      { value: "13", name: "port_eth0_eth_txd3", desc: "Connect port eth_txd3 from port group eth0 to this pad." }
                      { value: "14", name: "port_sdio1_sdio_clk", desc: "Connect port sdio_clk from port group sdio1 to this pad." }
                      { value: "15", name: "port_sdio1_sdio_cmd", desc: "Connect port sdio_cmd from port group sdio1 to this pad." }
                      { value: "16", name: "port_sdio1_sdio_data0", desc: "Connect port sdio_data0 from port group sdio1 to this pad." }
                      { value: "17", name: "port_sdio1_sdio_data1", desc: "Connect port sdio_data1 from port group sdio1 to this pad." }
                      { value: "18", name: "port_sdio1_sdio_data2", desc: "Connect port sdio_data2 from port group sdio1 to this pad." }
                      { value: "19", name: "port_sdio1_sdio_data3", desc: "Connect port sdio_data3 from port group sdio1 to this pad." }
                      { value: "20", name: "port_uart_cf3_uart_cts", desc: "Connect port uart_cts from port group uart_cf3 to this pad." }
                      { value: "21", name: "port_uart_cf3_uart_rts", desc: "Connect port uart_rts from port group uart_cf3 to this pad." }
                      { value: "22", name: "port_uart_cf3_uart_rx", desc: "Connect port uart_rx from port group uart_cf3 to this pad." }
                      { value: "23", name: "port_uart_cf3_uart_tx", desc: "Connect port uart_tx from port group uart_cf3 to this pad." }
                  ]
              }
          ]
      }

      {
          name: PAD_IO_G_05_CFG
          desc: '''
            Pad signal configuration.
          '''
          swaccess: "rw"
          fields: [
            {
                bits: "0"
                name: chip2pad
                desc: '''
                     The signal that connects to the pads TX driver
                '''
                swaccess: "rw"
                hwaccess: "hro"
                resval: "0"
            },
            {
                bits: "1"
                name: oen
                desc: '''
                     Output enable signal, active low
                '''
                swaccess: "rw"
                hwaccess: "hro"
                resval: "1"
            },
          ]
      }

       {
          name: PAD_IO_G_05_MUX_SEL
          desc: '''
              Pad signal port multiplex selection for pad pad_io_g_05. The programmed value defines which port
              is connected to the pad.
          '''
          swaccess: "rw"
          hwaccess: "hro"
          resval: 0
          fields: [
              {
                  bits: "4:0"
                  enum: [
                      { value: "0", name: "register", desc: "Connects the Pad to the internal configuration register."}
                      { value: "1", name: "port_eth0_eth_rst", desc: "Connect port eth_rst from port group eth0 to this pad." }
                      { value: "2", name: "port_eth0_eth_rxck", desc: "Connect port eth_rxck from port group eth0 to this pad." }
                      { value: "3", name: "port_eth0_eth_rxctl", desc: "Connect port eth_rxctl from port group eth0 to this pad." }
                      { value: "4", name: "port_eth0_eth_rxd0", desc: "Connect port eth_rxd0 from port group eth0 to this pad." }
                      { value: "5", name: "port_eth0_eth_rxd1", desc: "Connect port eth_rxd1 from port group eth0 to this pad." }
                      { value: "6", name: "port_eth0_eth_rxd2", desc: "Connect port eth_rxd2 from port group eth0 to this pad." }
                      { value: "7", name: "port_eth0_eth_rxd3", desc: "Connect port eth_rxd3 from port group eth0 to this pad." }
                      { value: "8", name: "port_eth0_eth_txck", desc: "Connect port eth_txck from port group eth0 to this pad." }
                      { value: "9", name: "port_eth0_eth_txctl", desc: "Connect port eth_txctl from port group eth0 to this pad." }
                      { value: "10", name: "port_eth0_eth_txd0", desc: "Connect port eth_txd0 from port group eth0 to this pad." }
                      { value: "11", name: "port_eth0_eth_txd1", desc: "Connect port eth_txd1 from port group eth0 to this pad." }
                      { value: "12", name: "port_eth0_eth_txd2", desc: "Connect port eth_txd2 from port group eth0 to this pad." }
                      { value: "13", name: "port_eth0_eth_txd3", desc: "Connect port eth_txd3 from port group eth0 to this pad." }
                      { value: "14", name: "port_sdio1_sdio_clk", desc: "Connect port sdio_clk from port group sdio1 to this pad." }
                      { value: "15", name: "port_sdio1_sdio_cmd", desc: "Connect port sdio_cmd from port group sdio1 to this pad." }
                      { value: "16", name: "port_sdio1_sdio_data0", desc: "Connect port sdio_data0 from port group sdio1 to this pad." }
                      { value: "17", name: "port_sdio1_sdio_data1", desc: "Connect port sdio_data1 from port group sdio1 to this pad." }
                      { value: "18", name: "port_sdio1_sdio_data2", desc: "Connect port sdio_data2 from port group sdio1 to this pad." }
                      { value: "19", name: "port_sdio1_sdio_data3", desc: "Connect port sdio_data3 from port group sdio1 to this pad." }
                      { value: "20", name: "port_uart_cf3_uart_cts", desc: "Connect port uart_cts from port group uart_cf3 to this pad." }
                      { value: "21", name: "port_uart_cf3_uart_rts", desc: "Connect port uart_rts from port group uart_cf3 to this pad." }
                      { value: "22", name: "port_uart_cf3_uart_rx", desc: "Connect port uart_rx from port group uart_cf3 to this pad." }
                      { value: "23", name: "port_uart_cf3_uart_tx", desc: "Connect port uart_tx from port group uart_cf3 to this pad." }
                  ]
              }
          ]
      }

      {
          name: PAD_IO_G_06_CFG
          desc: '''
            Pad signal configuration.
          '''
          swaccess: "rw"
          fields: [
            {
                bits: "0"
                name: chip2pad
                desc: '''
                     The signal that connects to the pads TX driver
                '''
                swaccess: "rw"
                hwaccess: "hro"
                resval: "0"
            },
            {
                bits: "1"
                name: oen
                desc: '''
                     Output enable signal, active low
                '''
                swaccess: "rw"
                hwaccess: "hro"
                resval: "1"
            },
          ]
      }

       {
          name: PAD_IO_G_06_MUX_SEL
          desc: '''
              Pad signal port multiplex selection for pad pad_io_g_06. The programmed value defines which port
              is connected to the pad.
          '''
          swaccess: "rw"
          hwaccess: "hro"
          resval: 0
          fields: [
              {
                  bits: "4:0"
                  enum: [
                      { value: "0", name: "register", desc: "Connects the Pad to the internal configuration register."}
                      { value: "1", name: "port_eth0_eth_rst", desc: "Connect port eth_rst from port group eth0 to this pad." }
                      { value: "2", name: "port_eth0_eth_rxck", desc: "Connect port eth_rxck from port group eth0 to this pad." }
                      { value: "3", name: "port_eth0_eth_rxctl", desc: "Connect port eth_rxctl from port group eth0 to this pad." }
                      { value: "4", name: "port_eth0_eth_rxd0", desc: "Connect port eth_rxd0 from port group eth0 to this pad." }
                      { value: "5", name: "port_eth0_eth_rxd1", desc: "Connect port eth_rxd1 from port group eth0 to this pad." }
                      { value: "6", name: "port_eth0_eth_rxd2", desc: "Connect port eth_rxd2 from port group eth0 to this pad." }
                      { value: "7", name: "port_eth0_eth_rxd3", desc: "Connect port eth_rxd3 from port group eth0 to this pad." }
                      { value: "8", name: "port_eth0_eth_txck", desc: "Connect port eth_txck from port group eth0 to this pad." }
                      { value: "9", name: "port_eth0_eth_txctl", desc: "Connect port eth_txctl from port group eth0 to this pad." }
                      { value: "10", name: "port_eth0_eth_txd0", desc: "Connect port eth_txd0 from port group eth0 to this pad." }
                      { value: "11", name: "port_eth0_eth_txd1", desc: "Connect port eth_txd1 from port group eth0 to this pad." }
                      { value: "12", name: "port_eth0_eth_txd2", desc: "Connect port eth_txd2 from port group eth0 to this pad." }
                      { value: "13", name: "port_eth0_eth_txd3", desc: "Connect port eth_txd3 from port group eth0 to this pad." }
                      { value: "14", name: "port_sdio1_sdio_clk", desc: "Connect port sdio_clk from port group sdio1 to this pad." }
                      { value: "15", name: "port_sdio1_sdio_cmd", desc: "Connect port sdio_cmd from port group sdio1 to this pad." }
                      { value: "16", name: "port_sdio1_sdio_data0", desc: "Connect port sdio_data0 from port group sdio1 to this pad." }
                      { value: "17", name: "port_sdio1_sdio_data1", desc: "Connect port sdio_data1 from port group sdio1 to this pad." }
                      { value: "18", name: "port_sdio1_sdio_data2", desc: "Connect port sdio_data2 from port group sdio1 to this pad." }
                      { value: "19", name: "port_sdio1_sdio_data3", desc: "Connect port sdio_data3 from port group sdio1 to this pad." }
                      { value: "20", name: "port_uart_cf3_uart_cts", desc: "Connect port uart_cts from port group uart_cf3 to this pad." }
                      { value: "21", name: "port_uart_cf3_uart_rts", desc: "Connect port uart_rts from port group uart_cf3 to this pad." }
                      { value: "22", name: "port_uart_cf3_uart_rx", desc: "Connect port uart_rx from port group uart_cf3 to this pad." }
                      { value: "23", name: "port_uart_cf3_uart_tx", desc: "Connect port uart_tx from port group uart_cf3 to this pad." }
                  ]
              }
          ]
      }

      {
          name: PAD_IO_G_07_CFG
          desc: '''
            Pad signal configuration.
          '''
          swaccess: "rw"
          fields: [
            {
                bits: "0"
                name: chip2pad
                desc: '''
                     The signal that connects to the pads TX driver
                '''
                swaccess: "rw"
                hwaccess: "hro"
                resval: "0"
            },
            {
                bits: "1"
                name: oen
                desc: '''
                     Output enable signal, active low
                '''
                swaccess: "rw"
                hwaccess: "hro"
                resval: "1"
            },
          ]
      }

       {
          name: PAD_IO_G_07_MUX_SEL
          desc: '''
              Pad signal port multiplex selection for pad pad_io_g_07. The programmed value defines which port
              is connected to the pad.
          '''
          swaccess: "rw"
          hwaccess: "hro"
          resval: 0
          fields: [
              {
                  bits: "4:0"
                  enum: [
                      { value: "0", name: "register", desc: "Connects the Pad to the internal configuration register."}
                      { value: "1", name: "port_eth0_eth_rst", desc: "Connect port eth_rst from port group eth0 to this pad." }
                      { value: "2", name: "port_eth0_eth_rxck", desc: "Connect port eth_rxck from port group eth0 to this pad." }
                      { value: "3", name: "port_eth0_eth_rxctl", desc: "Connect port eth_rxctl from port group eth0 to this pad." }
                      { value: "4", name: "port_eth0_eth_rxd0", desc: "Connect port eth_rxd0 from port group eth0 to this pad." }
                      { value: "5", name: "port_eth0_eth_rxd1", desc: "Connect port eth_rxd1 from port group eth0 to this pad." }
                      { value: "6", name: "port_eth0_eth_rxd2", desc: "Connect port eth_rxd2 from port group eth0 to this pad." }
                      { value: "7", name: "port_eth0_eth_rxd3", desc: "Connect port eth_rxd3 from port group eth0 to this pad." }
                      { value: "8", name: "port_eth0_eth_txck", desc: "Connect port eth_txck from port group eth0 to this pad." }
                      { value: "9", name: "port_eth0_eth_txctl", desc: "Connect port eth_txctl from port group eth0 to this pad." }
                      { value: "10", name: "port_eth0_eth_txd0", desc: "Connect port eth_txd0 from port group eth0 to this pad." }
                      { value: "11", name: "port_eth0_eth_txd1", desc: "Connect port eth_txd1 from port group eth0 to this pad." }
                      { value: "12", name: "port_eth0_eth_txd2", desc: "Connect port eth_txd2 from port group eth0 to this pad." }
                      { value: "13", name: "port_eth0_eth_txd3", desc: "Connect port eth_txd3 from port group eth0 to this pad." }
                      { value: "14", name: "port_sdio1_sdio_clk", desc: "Connect port sdio_clk from port group sdio1 to this pad." }
                      { value: "15", name: "port_sdio1_sdio_cmd", desc: "Connect port sdio_cmd from port group sdio1 to this pad." }
                      { value: "16", name: "port_sdio1_sdio_data0", desc: "Connect port sdio_data0 from port group sdio1 to this pad." }
                      { value: "17", name: "port_sdio1_sdio_data1", desc: "Connect port sdio_data1 from port group sdio1 to this pad." }
                      { value: "18", name: "port_sdio1_sdio_data2", desc: "Connect port sdio_data2 from port group sdio1 to this pad." }
                      { value: "19", name: "port_sdio1_sdio_data3", desc: "Connect port sdio_data3 from port group sdio1 to this pad." }
                      { value: "20", name: "port_uart_cf3_uart_cts", desc: "Connect port uart_cts from port group uart_cf3 to this pad." }
                      { value: "21", name: "port_uart_cf3_uart_rts", desc: "Connect port uart_rts from port group uart_cf3 to this pad." }
                      { value: "22", name: "port_uart_cf3_uart_rx", desc: "Connect port uart_rx from port group uart_cf3 to this pad." }
                      { value: "23", name: "port_uart_cf3_uart_tx", desc: "Connect port uart_tx from port group uart_cf3 to this pad." }
                  ]
              }
          ]
      }

      {
          name: PAD_IO_G_08_CFG
          desc: '''
            Pad signal configuration.
          '''
          swaccess: "rw"
          fields: [
            {
                bits: "0"
                name: chip2pad
                desc: '''
                     The signal that connects to the pads TX driver
                '''
                swaccess: "rw"
                hwaccess: "hro"
                resval: "0"
            },
            {
                bits: "1"
                name: oen
                desc: '''
                     Output enable signal, active low
                '''
                swaccess: "rw"
                hwaccess: "hro"
                resval: "1"
            },
          ]
      }

       {
          name: PAD_IO_G_08_MUX_SEL
          desc: '''
              Pad signal port multiplex selection for pad pad_io_g_08. The programmed value defines which port
              is connected to the pad.
          '''
          swaccess: "rw"
          hwaccess: "hro"
          resval: 0
          fields: [
              {
                  bits: "4:0"
                  enum: [
                      { value: "0", name: "register", desc: "Connects the Pad to the internal configuration register."}
                      { value: "1", name: "port_eth0_eth_rst", desc: "Connect port eth_rst from port group eth0 to this pad." }
                      { value: "2", name: "port_eth0_eth_rxck", desc: "Connect port eth_rxck from port group eth0 to this pad." }
                      { value: "3", name: "port_eth0_eth_rxctl", desc: "Connect port eth_rxctl from port group eth0 to this pad." }
                      { value: "4", name: "port_eth0_eth_rxd0", desc: "Connect port eth_rxd0 from port group eth0 to this pad." }
                      { value: "5", name: "port_eth0_eth_rxd1", desc: "Connect port eth_rxd1 from port group eth0 to this pad." }
                      { value: "6", name: "port_eth0_eth_rxd2", desc: "Connect port eth_rxd2 from port group eth0 to this pad." }
                      { value: "7", name: "port_eth0_eth_rxd3", desc: "Connect port eth_rxd3 from port group eth0 to this pad." }
                      { value: "8", name: "port_eth0_eth_txck", desc: "Connect port eth_txck from port group eth0 to this pad." }
                      { value: "9", name: "port_eth0_eth_txctl", desc: "Connect port eth_txctl from port group eth0 to this pad." }
                      { value: "10", name: "port_eth0_eth_txd0", desc: "Connect port eth_txd0 from port group eth0 to this pad." }
                      { value: "11", name: "port_eth0_eth_txd1", desc: "Connect port eth_txd1 from port group eth0 to this pad." }
                      { value: "12", name: "port_eth0_eth_txd2", desc: "Connect port eth_txd2 from port group eth0 to this pad." }
                      { value: "13", name: "port_eth0_eth_txd3", desc: "Connect port eth_txd3 from port group eth0 to this pad." }
                      { value: "14", name: "port_sdio1_sdio_clk", desc: "Connect port sdio_clk from port group sdio1 to this pad." }
                      { value: "15", name: "port_sdio1_sdio_cmd", desc: "Connect port sdio_cmd from port group sdio1 to this pad." }
                      { value: "16", name: "port_sdio1_sdio_data0", desc: "Connect port sdio_data0 from port group sdio1 to this pad." }
                      { value: "17", name: "port_sdio1_sdio_data1", desc: "Connect port sdio_data1 from port group sdio1 to this pad." }
                      { value: "18", name: "port_sdio1_sdio_data2", desc: "Connect port sdio_data2 from port group sdio1 to this pad." }
                      { value: "19", name: "port_sdio1_sdio_data3", desc: "Connect port sdio_data3 from port group sdio1 to this pad." }
                      { value: "20", name: "port_uart_cf3_uart_cts", desc: "Connect port uart_cts from port group uart_cf3 to this pad." }
                      { value: "21", name: "port_uart_cf3_uart_rts", desc: "Connect port uart_rts from port group uart_cf3 to this pad." }
                      { value: "22", name: "port_uart_cf3_uart_rx", desc: "Connect port uart_rx from port group uart_cf3 to this pad." }
                      { value: "23", name: "port_uart_cf3_uart_tx", desc: "Connect port uart_tx from port group uart_cf3 to this pad." }
                  ]
              }
          ]
      }

      {
          name: PAD_IO_G_09_CFG
          desc: '''
            Pad signal configuration.
          '''
          swaccess: "rw"
          fields: [
            {
                bits: "0"
                name: chip2pad
                desc: '''
                     The signal that connects to the pads TX driver
                '''
                swaccess: "rw"
                hwaccess: "hro"
                resval: "0"
            },
            {
                bits: "1"
                name: oen
                desc: '''
                     Output enable signal, active low
                '''
                swaccess: "rw"
                hwaccess: "hro"
                resval: "1"
            },
          ]
      }

       {
          name: PAD_IO_G_09_MUX_SEL
          desc: '''
              Pad signal port multiplex selection for pad pad_io_g_09. The programmed value defines which port
              is connected to the pad.
          '''
          swaccess: "rw"
          hwaccess: "hro"
          resval: 0
          fields: [
              {
                  bits: "4:0"
                  enum: [
                      { value: "0", name: "register", desc: "Connects the Pad to the internal configuration register."}
                      { value: "1", name: "port_eth0_eth_rst", desc: "Connect port eth_rst from port group eth0 to this pad." }
                      { value: "2", name: "port_eth0_eth_rxck", desc: "Connect port eth_rxck from port group eth0 to this pad." }
                      { value: "3", name: "port_eth0_eth_rxctl", desc: "Connect port eth_rxctl from port group eth0 to this pad." }
                      { value: "4", name: "port_eth0_eth_rxd0", desc: "Connect port eth_rxd0 from port group eth0 to this pad." }
                      { value: "5", name: "port_eth0_eth_rxd1", desc: "Connect port eth_rxd1 from port group eth0 to this pad." }
                      { value: "6", name: "port_eth0_eth_rxd2", desc: "Connect port eth_rxd2 from port group eth0 to this pad." }
                      { value: "7", name: "port_eth0_eth_rxd3", desc: "Connect port eth_rxd3 from port group eth0 to this pad." }
                      { value: "8", name: "port_eth0_eth_txck", desc: "Connect port eth_txck from port group eth0 to this pad." }
                      { value: "9", name: "port_eth0_eth_txctl", desc: "Connect port eth_txctl from port group eth0 to this pad." }
                      { value: "10", name: "port_eth0_eth_txd0", desc: "Connect port eth_txd0 from port group eth0 to this pad." }
                      { value: "11", name: "port_eth0_eth_txd1", desc: "Connect port eth_txd1 from port group eth0 to this pad." }
                      { value: "12", name: "port_eth0_eth_txd2", desc: "Connect port eth_txd2 from port group eth0 to this pad." }
                      { value: "13", name: "port_eth0_eth_txd3", desc: "Connect port eth_txd3 from port group eth0 to this pad." }
                      { value: "14", name: "port_sdio1_sdio_clk", desc: "Connect port sdio_clk from port group sdio1 to this pad." }
                      { value: "15", name: "port_sdio1_sdio_cmd", desc: "Connect port sdio_cmd from port group sdio1 to this pad." }
                      { value: "16", name: "port_sdio1_sdio_data0", desc: "Connect port sdio_data0 from port group sdio1 to this pad." }
                      { value: "17", name: "port_sdio1_sdio_data1", desc: "Connect port sdio_data1 from port group sdio1 to this pad." }
                      { value: "18", name: "port_sdio1_sdio_data2", desc: "Connect port sdio_data2 from port group sdio1 to this pad." }
                      { value: "19", name: "port_sdio1_sdio_data3", desc: "Connect port sdio_data3 from port group sdio1 to this pad." }
                      { value: "20", name: "port_uart_cf3_uart_cts", desc: "Connect port uart_cts from port group uart_cf3 to this pad." }
                      { value: "21", name: "port_uart_cf3_uart_rts", desc: "Connect port uart_rts from port group uart_cf3 to this pad." }
                      { value: "22", name: "port_uart_cf3_uart_rx", desc: "Connect port uart_rx from port group uart_cf3 to this pad." }
                      { value: "23", name: "port_uart_cf3_uart_tx", desc: "Connect port uart_tx from port group uart_cf3 to this pad." }
                  ]
              }
          ]
      }

      {
          name: PAD_IO_G_10_CFG
          desc: '''
            Pad signal configuration.
          '''
          swaccess: "rw"
          fields: [
            {
                bits: "0"
                name: chip2pad
                desc: '''
                     The signal that connects to the pads TX driver
                '''
                swaccess: "rw"
                hwaccess: "hro"
                resval: "0"
            },
            {
                bits: "1"
                name: oen
                desc: '''
                     Output enable signal, active low
                '''
                swaccess: "rw"
                hwaccess: "hro"
                resval: "1"
            },
          ]
      }

       {
          name: PAD_IO_G_10_MUX_SEL
          desc: '''
              Pad signal port multiplex selection for pad pad_io_g_10. The programmed value defines which port
              is connected to the pad.
          '''
          swaccess: "rw"
          hwaccess: "hro"
          resval: 0
          fields: [
              {
                  bits: "4:0"
                  enum: [
                      { value: "0", name: "register", desc: "Connects the Pad to the internal configuration register."}
                      { value: "1", name: "port_eth0_eth_rst", desc: "Connect port eth_rst from port group eth0 to this pad." }
                      { value: "2", name: "port_eth0_eth_rxck", desc: "Connect port eth_rxck from port group eth0 to this pad." }
                      { value: "3", name: "port_eth0_eth_rxctl", desc: "Connect port eth_rxctl from port group eth0 to this pad." }
                      { value: "4", name: "port_eth0_eth_rxd0", desc: "Connect port eth_rxd0 from port group eth0 to this pad." }
                      { value: "5", name: "port_eth0_eth_rxd1", desc: "Connect port eth_rxd1 from port group eth0 to this pad." }
                      { value: "6", name: "port_eth0_eth_rxd2", desc: "Connect port eth_rxd2 from port group eth0 to this pad." }
                      { value: "7", name: "port_eth0_eth_rxd3", desc: "Connect port eth_rxd3 from port group eth0 to this pad." }
                      { value: "8", name: "port_eth0_eth_txck", desc: "Connect port eth_txck from port group eth0 to this pad." }
                      { value: "9", name: "port_eth0_eth_txctl", desc: "Connect port eth_txctl from port group eth0 to this pad." }
                      { value: "10", name: "port_eth0_eth_txd0", desc: "Connect port eth_txd0 from port group eth0 to this pad." }
                      { value: "11", name: "port_eth0_eth_txd1", desc: "Connect port eth_txd1 from port group eth0 to this pad." }
                      { value: "12", name: "port_eth0_eth_txd2", desc: "Connect port eth_txd2 from port group eth0 to this pad." }
                      { value: "13", name: "port_eth0_eth_txd3", desc: "Connect port eth_txd3 from port group eth0 to this pad." }
                      { value: "14", name: "port_sdio1_sdio_clk", desc: "Connect port sdio_clk from port group sdio1 to this pad." }
                      { value: "15", name: "port_sdio1_sdio_cmd", desc: "Connect port sdio_cmd from port group sdio1 to this pad." }
                      { value: "16", name: "port_sdio1_sdio_data0", desc: "Connect port sdio_data0 from port group sdio1 to this pad." }
                      { value: "17", name: "port_sdio1_sdio_data1", desc: "Connect port sdio_data1 from port group sdio1 to this pad." }
                      { value: "18", name: "port_sdio1_sdio_data2", desc: "Connect port sdio_data2 from port group sdio1 to this pad." }
                      { value: "19", name: "port_sdio1_sdio_data3", desc: "Connect port sdio_data3 from port group sdio1 to this pad." }
                      { value: "20", name: "port_uart_cf3_uart_cts", desc: "Connect port uart_cts from port group uart_cf3 to this pad." }
                      { value: "21", name: "port_uart_cf3_uart_rts", desc: "Connect port uart_rts from port group uart_cf3 to this pad." }
                      { value: "22", name: "port_uart_cf3_uart_rx", desc: "Connect port uart_rx from port group uart_cf3 to this pad." }
                      { value: "23", name: "port_uart_cf3_uart_tx", desc: "Connect port uart_tx from port group uart_cf3 to this pad." }
                  ]
              }
          ]
      }

      {
          name: PAD_IO_G_11_CFG
          desc: '''
            Pad signal configuration.
          '''
          swaccess: "rw"
          fields: [
            {
                bits: "0"
                name: chip2pad
                desc: '''
                     The signal that connects to the pads TX driver
                '''
                swaccess: "rw"
                hwaccess: "hro"
                resval: "0"
            },
            {
                bits: "1"
                name: oen
                desc: '''
                     Output enable signal, active low
                '''
                swaccess: "rw"
                hwaccess: "hro"
                resval: "1"
            },
          ]
      }

       {
          name: PAD_IO_G_11_MUX_SEL
          desc: '''
              Pad signal port multiplex selection for pad pad_io_g_11. The programmed value defines which port
              is connected to the pad.
          '''
          swaccess: "rw"
          hwaccess: "hro"
          resval: 0
          fields: [
              {
                  bits: "4:0"
                  enum: [
                      { value: "0", name: "register", desc: "Connects the Pad to the internal configuration register."}
                      { value: "1", name: "port_eth0_eth_rst", desc: "Connect port eth_rst from port group eth0 to this pad." }
                      { value: "2", name: "port_eth0_eth_rxck", desc: "Connect port eth_rxck from port group eth0 to this pad." }
                      { value: "3", name: "port_eth0_eth_rxctl", desc: "Connect port eth_rxctl from port group eth0 to this pad." }
                      { value: "4", name: "port_eth0_eth_rxd0", desc: "Connect port eth_rxd0 from port group eth0 to this pad." }
                      { value: "5", name: "port_eth0_eth_rxd1", desc: "Connect port eth_rxd1 from port group eth0 to this pad." }
                      { value: "6", name: "port_eth0_eth_rxd2", desc: "Connect port eth_rxd2 from port group eth0 to this pad." }
                      { value: "7", name: "port_eth0_eth_rxd3", desc: "Connect port eth_rxd3 from port group eth0 to this pad." }
                      { value: "8", name: "port_eth0_eth_txck", desc: "Connect port eth_txck from port group eth0 to this pad." }
                      { value: "9", name: "port_eth0_eth_txctl", desc: "Connect port eth_txctl from port group eth0 to this pad." }
                      { value: "10", name: "port_eth0_eth_txd0", desc: "Connect port eth_txd0 from port group eth0 to this pad." }
                      { value: "11", name: "port_eth0_eth_txd1", desc: "Connect port eth_txd1 from port group eth0 to this pad." }
                      { value: "12", name: "port_eth0_eth_txd2", desc: "Connect port eth_txd2 from port group eth0 to this pad." }
                      { value: "13", name: "port_eth0_eth_txd3", desc: "Connect port eth_txd3 from port group eth0 to this pad." }
                      { value: "14", name: "port_sdio1_sdio_clk", desc: "Connect port sdio_clk from port group sdio1 to this pad." }
                      { value: "15", name: "port_sdio1_sdio_cmd", desc: "Connect port sdio_cmd from port group sdio1 to this pad." }
                      { value: "16", name: "port_sdio1_sdio_data0", desc: "Connect port sdio_data0 from port group sdio1 to this pad." }
                      { value: "17", name: "port_sdio1_sdio_data1", desc: "Connect port sdio_data1 from port group sdio1 to this pad." }
                      { value: "18", name: "port_sdio1_sdio_data2", desc: "Connect port sdio_data2 from port group sdio1 to this pad." }
                      { value: "19", name: "port_sdio1_sdio_data3", desc: "Connect port sdio_data3 from port group sdio1 to this pad." }
                      { value: "20", name: "port_uart_cf3_uart_cts", desc: "Connect port uart_cts from port group uart_cf3 to this pad." }
                      { value: "21", name: "port_uart_cf3_uart_rts", desc: "Connect port uart_rts from port group uart_cf3 to this pad." }
                      { value: "22", name: "port_uart_cf3_uart_rx", desc: "Connect port uart_rx from port group uart_cf3 to this pad." }
                      { value: "23", name: "port_uart_cf3_uart_tx", desc: "Connect port uart_tx from port group uart_cf3 to this pad." }
                  ]
              }
          ]
      }

      {
          name: PAD_IO_G_12_CFG
          desc: '''
            Pad signal configuration.
          '''
          swaccess: "rw"
          fields: [
            {
                bits: "0"
                name: chip2pad
                desc: '''
                     The signal that connects to the pads TX driver
                '''
                swaccess: "rw"
                hwaccess: "hro"
                resval: "0"
            },
            {
                bits: "1"
                name: oen
                desc: '''
                     Output enable signal, active low
                '''
                swaccess: "rw"
                hwaccess: "hro"
                resval: "1"
            },
          ]
      }

       {
          name: PAD_IO_G_12_MUX_SEL
          desc: '''
              Pad signal port multiplex selection for pad pad_io_g_12. The programmed value defines which port
              is connected to the pad.
          '''
          swaccess: "rw"
          hwaccess: "hro"
          resval: 0
          fields: [
              {
                  bits: "4:0"
                  enum: [
                      { value: "0", name: "register", desc: "Connects the Pad to the internal configuration register."}
                      { value: "1", name: "port_eth0_eth_rst", desc: "Connect port eth_rst from port group eth0 to this pad." }
                      { value: "2", name: "port_eth0_eth_rxck", desc: "Connect port eth_rxck from port group eth0 to this pad." }
                      { value: "3", name: "port_eth0_eth_rxctl", desc: "Connect port eth_rxctl from port group eth0 to this pad." }
                      { value: "4", name: "port_eth0_eth_rxd0", desc: "Connect port eth_rxd0 from port group eth0 to this pad." }
                      { value: "5", name: "port_eth0_eth_rxd1", desc: "Connect port eth_rxd1 from port group eth0 to this pad." }
                      { value: "6", name: "port_eth0_eth_rxd2", desc: "Connect port eth_rxd2 from port group eth0 to this pad." }
                      { value: "7", name: "port_eth0_eth_rxd3", desc: "Connect port eth_rxd3 from port group eth0 to this pad." }
                      { value: "8", name: "port_eth0_eth_txck", desc: "Connect port eth_txck from port group eth0 to this pad." }
                      { value: "9", name: "port_eth0_eth_txctl", desc: "Connect port eth_txctl from port group eth0 to this pad." }
                      { value: "10", name: "port_eth0_eth_txd0", desc: "Connect port eth_txd0 from port group eth0 to this pad." }
                      { value: "11", name: "port_eth0_eth_txd1", desc: "Connect port eth_txd1 from port group eth0 to this pad." }
                      { value: "12", name: "port_eth0_eth_txd2", desc: "Connect port eth_txd2 from port group eth0 to this pad." }
                      { value: "13", name: "port_eth0_eth_txd3", desc: "Connect port eth_txd3 from port group eth0 to this pad." }
                      { value: "14", name: "port_sdio1_sdio_clk", desc: "Connect port sdio_clk from port group sdio1 to this pad." }
                      { value: "15", name: "port_sdio1_sdio_cmd", desc: "Connect port sdio_cmd from port group sdio1 to this pad." }
                      { value: "16", name: "port_sdio1_sdio_data0", desc: "Connect port sdio_data0 from port group sdio1 to this pad." }
                      { value: "17", name: "port_sdio1_sdio_data1", desc: "Connect port sdio_data1 from port group sdio1 to this pad." }
                      { value: "18", name: "port_sdio1_sdio_data2", desc: "Connect port sdio_data2 from port group sdio1 to this pad." }
                      { value: "19", name: "port_sdio1_sdio_data3", desc: "Connect port sdio_data3 from port group sdio1 to this pad." }
                      { value: "20", name: "port_uart_cf3_uart_cts", desc: "Connect port uart_cts from port group uart_cf3 to this pad." }
                      { value: "21", name: "port_uart_cf3_uart_rts", desc: "Connect port uart_rts from port group uart_cf3 to this pad." }
                      { value: "22", name: "port_uart_cf3_uart_rx", desc: "Connect port uart_rx from port group uart_cf3 to this pad." }
                      { value: "23", name: "port_uart_cf3_uart_tx", desc: "Connect port uart_tx from port group uart_cf3 to this pad." }
                  ]
              }
          ]
      }

      {
          name: PAD_IO_G_13_CFG
          desc: '''
            Pad signal configuration.
          '''
          swaccess: "rw"
          fields: [
            {
                bits: "0"
                name: chip2pad
                desc: '''
                     The signal that connects to the pads TX driver
                '''
                swaccess: "rw"
                hwaccess: "hro"
                resval: "0"
            },
            {
                bits: "1"
                name: oen
                desc: '''
                     Output enable signal, active low
                '''
                swaccess: "rw"
                hwaccess: "hro"
                resval: "1"
            },
          ]
      }

       {
          name: PAD_IO_G_13_MUX_SEL
          desc: '''
              Pad signal port multiplex selection for pad pad_io_g_13. The programmed value defines which port
              is connected to the pad.
          '''
          swaccess: "rw"
          hwaccess: "hro"
          resval: 0
          fields: [
              {
                  bits: "4:0"
                  enum: [
                      { value: "0", name: "register", desc: "Connects the Pad to the internal configuration register."}
                      { value: "1", name: "port_eth0_eth_rst", desc: "Connect port eth_rst from port group eth0 to this pad." }
                      { value: "2", name: "port_eth0_eth_rxck", desc: "Connect port eth_rxck from port group eth0 to this pad." }
                      { value: "3", name: "port_eth0_eth_rxctl", desc: "Connect port eth_rxctl from port group eth0 to this pad." }
                      { value: "4", name: "port_eth0_eth_rxd0", desc: "Connect port eth_rxd0 from port group eth0 to this pad." }
                      { value: "5", name: "port_eth0_eth_rxd1", desc: "Connect port eth_rxd1 from port group eth0 to this pad." }
                      { value: "6", name: "port_eth0_eth_rxd2", desc: "Connect port eth_rxd2 from port group eth0 to this pad." }
                      { value: "7", name: "port_eth0_eth_rxd3", desc: "Connect port eth_rxd3 from port group eth0 to this pad." }
                      { value: "8", name: "port_eth0_eth_txck", desc: "Connect port eth_txck from port group eth0 to this pad." }
                      { value: "9", name: "port_eth0_eth_txctl", desc: "Connect port eth_txctl from port group eth0 to this pad." }
                      { value: "10", name: "port_eth0_eth_txd0", desc: "Connect port eth_txd0 from port group eth0 to this pad." }
                      { value: "11", name: "port_eth0_eth_txd1", desc: "Connect port eth_txd1 from port group eth0 to this pad." }
                      { value: "12", name: "port_eth0_eth_txd2", desc: "Connect port eth_txd2 from port group eth0 to this pad." }
                      { value: "13", name: "port_eth0_eth_txd3", desc: "Connect port eth_txd3 from port group eth0 to this pad." }
                      { value: "14", name: "port_sdio1_sdio_clk", desc: "Connect port sdio_clk from port group sdio1 to this pad." }
                      { value: "15", name: "port_sdio1_sdio_cmd", desc: "Connect port sdio_cmd from port group sdio1 to this pad." }
                      { value: "16", name: "port_sdio1_sdio_data0", desc: "Connect port sdio_data0 from port group sdio1 to this pad." }
                      { value: "17", name: "port_sdio1_sdio_data1", desc: "Connect port sdio_data1 from port group sdio1 to this pad." }
                      { value: "18", name: "port_sdio1_sdio_data2", desc: "Connect port sdio_data2 from port group sdio1 to this pad." }
                      { value: "19", name: "port_sdio1_sdio_data3", desc: "Connect port sdio_data3 from port group sdio1 to this pad." }
                      { value: "20", name: "port_uart_cf3_uart_cts", desc: "Connect port uart_cts from port group uart_cf3 to this pad." }
                      { value: "21", name: "port_uart_cf3_uart_rts", desc: "Connect port uart_rts from port group uart_cf3 to this pad." }
                      { value: "22", name: "port_uart_cf3_uart_rx", desc: "Connect port uart_rx from port group uart_cf3 to this pad." }
                      { value: "23", name: "port_uart_cf3_uart_tx", desc: "Connect port uart_tx from port group uart_cf3 to this pad." }
                  ]
              }
          ]
      }

      {
          name: PAD_IO_G_14_CFG
          desc: '''
            Pad signal configuration.
          '''
          swaccess: "rw"
          fields: [
            {
                bits: "0"
                name: chip2pad
                desc: '''
                     The signal that connects to the pads TX driver
                '''
                swaccess: "rw"
                hwaccess: "hro"
                resval: "0"
            },
            {
                bits: "1"
                name: oen
                desc: '''
                     Output enable signal, active low
                '''
                swaccess: "rw"
                hwaccess: "hro"
                resval: "1"
            },
          ]
      }

       {
          name: PAD_IO_G_14_MUX_SEL
          desc: '''
              Pad signal port multiplex selection for pad pad_io_g_14. The programmed value defines which port
              is connected to the pad.
          '''
          swaccess: "rw"
          hwaccess: "hro"
          resval: 0
          fields: [
              {
                  bits: "4:0"
                  enum: [
                      { value: "0", name: "register", desc: "Connects the Pad to the internal configuration register."}
                      { value: "1", name: "port_eth0_eth_rst", desc: "Connect port eth_rst from port group eth0 to this pad." }
                      { value: "2", name: "port_eth0_eth_rxck", desc: "Connect port eth_rxck from port group eth0 to this pad." }
                      { value: "3", name: "port_eth0_eth_rxctl", desc: "Connect port eth_rxctl from port group eth0 to this pad." }
                      { value: "4", name: "port_eth0_eth_rxd0", desc: "Connect port eth_rxd0 from port group eth0 to this pad." }
                      { value: "5", name: "port_eth0_eth_rxd1", desc: "Connect port eth_rxd1 from port group eth0 to this pad." }
                      { value: "6", name: "port_eth0_eth_rxd2", desc: "Connect port eth_rxd2 from port group eth0 to this pad." }
                      { value: "7", name: "port_eth0_eth_rxd3", desc: "Connect port eth_rxd3 from port group eth0 to this pad." }
                      { value: "8", name: "port_eth0_eth_txck", desc: "Connect port eth_txck from port group eth0 to this pad." }
                      { value: "9", name: "port_eth0_eth_txctl", desc: "Connect port eth_txctl from port group eth0 to this pad." }
                      { value: "10", name: "port_eth0_eth_txd0", desc: "Connect port eth_txd0 from port group eth0 to this pad." }
                      { value: "11", name: "port_eth0_eth_txd1", desc: "Connect port eth_txd1 from port group eth0 to this pad." }
                      { value: "12", name: "port_eth0_eth_txd2", desc: "Connect port eth_txd2 from port group eth0 to this pad." }
                      { value: "13", name: "port_eth0_eth_txd3", desc: "Connect port eth_txd3 from port group eth0 to this pad." }
                      { value: "14", name: "port_sdio1_sdio_clk", desc: "Connect port sdio_clk from port group sdio1 to this pad." }
                      { value: "15", name: "port_sdio1_sdio_cmd", desc: "Connect port sdio_cmd from port group sdio1 to this pad." }
                      { value: "16", name: "port_sdio1_sdio_data0", desc: "Connect port sdio_data0 from port group sdio1 to this pad." }
                      { value: "17", name: "port_sdio1_sdio_data1", desc: "Connect port sdio_data1 from port group sdio1 to this pad." }
                      { value: "18", name: "port_sdio1_sdio_data2", desc: "Connect port sdio_data2 from port group sdio1 to this pad." }
                      { value: "19", name: "port_sdio1_sdio_data3", desc: "Connect port sdio_data3 from port group sdio1 to this pad." }
                      { value: "20", name: "port_uart_cf3_uart_cts", desc: "Connect port uart_cts from port group uart_cf3 to this pad." }
                      { value: "21", name: "port_uart_cf3_uart_rts", desc: "Connect port uart_rts from port group uart_cf3 to this pad." }
                      { value: "22", name: "port_uart_cf3_uart_rx", desc: "Connect port uart_rx from port group uart_cf3 to this pad." }
                      { value: "23", name: "port_uart_cf3_uart_tx", desc: "Connect port uart_tx from port group uart_cf3 to this pad." }
                  ]
              }
          ]
      }

      {
          name: PAD_PWM0_CFG
          desc: '''
            Pad signal configuration.
          '''
          swaccess: "rw"
          fields: [
            {
                bits: "0"
                name: chip2pad
                desc: '''
                     The signal that connects to the pads TX driver
                '''
                swaccess: "rw"
                hwaccess: "hro"
                resval: "0"
            },
            {
                bits: "1"
                name: oen
                desc: '''
                     Output enable signal, active low
                '''
                swaccess: "rw"
                hwaccess: "hro"
                resval: "1"
            },
          ]
      }

       {
          name: PAD_PWM0_MUX_SEL
          desc: '''
              Pad signal port multiplex selection for pad pad_pwm0. The programmed value defines which port
              is connected to the pad.
          '''
          swaccess: "rw"
          hwaccess: "hro"
          resval: 0
          fields: [
              {
                  bits: "3:0"
                  enum: [
                      { value: "0", name: "register", desc: "Connects the Pad to the internal configuration register."}
                      { value: "1", name: "port_pwm_pwm0", desc: "Connect port pwm0 from port group pwm to this pad." }
                      { value: "2", name: "port_pwm_pwm1", desc: "Connect port pwm1 from port group pwm to this pad." }
                      { value: "3", name: "port_pwm_pwm2", desc: "Connect port pwm2 from port group pwm to this pad." }
                      { value: "4", name: "port_pwm_pwm3", desc: "Connect port pwm3 from port group pwm to this pad." }
                      { value: "5", name: "port_pwm_pwm4", desc: "Connect port pwm4 from port group pwm to this pad." }
                      { value: "6", name: "port_pwm_pwm5", desc: "Connect port pwm5 from port group pwm to this pad." }
                      { value: "7", name: "port_pwm_pwm6", desc: "Connect port pwm6 from port group pwm to this pad." }
                      { value: "8", name: "port_pwm_pwm7", desc: "Connect port pwm7 from port group pwm to this pad." }
                  ]
              }
          ]
      }

      {
          name: PAD_PWM1_CFG
          desc: '''
            Pad signal configuration.
          '''
          swaccess: "rw"
          fields: [
            {
                bits: "0"
                name: chip2pad
                desc: '''
                     The signal that connects to the pads TX driver
                '''
                swaccess: "rw"
                hwaccess: "hro"
                resval: "0"
            },
            {
                bits: "1"
                name: oen
                desc: '''
                     Output enable signal, active low
                '''
                swaccess: "rw"
                hwaccess: "hro"
                resval: "1"
            },
          ]
      }

       {
          name: PAD_PWM1_MUX_SEL
          desc: '''
              Pad signal port multiplex selection for pad pad_pwm1. The programmed value defines which port
              is connected to the pad.
          '''
          swaccess: "rw"
          hwaccess: "hro"
          resval: 0
          fields: [
              {
                  bits: "3:0"
                  enum: [
                      { value: "0", name: "register", desc: "Connects the Pad to the internal configuration register."}
                      { value: "1", name: "port_pwm_pwm0", desc: "Connect port pwm0 from port group pwm to this pad." }
                      { value: "2", name: "port_pwm_pwm1", desc: "Connect port pwm1 from port group pwm to this pad." }
                      { value: "3", name: "port_pwm_pwm2", desc: "Connect port pwm2 from port group pwm to this pad." }
                      { value: "4", name: "port_pwm_pwm3", desc: "Connect port pwm3 from port group pwm to this pad." }
                      { value: "5", name: "port_pwm_pwm4", desc: "Connect port pwm4 from port group pwm to this pad." }
                      { value: "6", name: "port_pwm_pwm5", desc: "Connect port pwm5 from port group pwm to this pad." }
                      { value: "7", name: "port_pwm_pwm6", desc: "Connect port pwm6 from port group pwm to this pad." }
                      { value: "8", name: "port_pwm_pwm7", desc: "Connect port pwm7 from port group pwm to this pad." }
                  ]
              }
          ]
      }

      {
          name: PAD_PWM2_CFG
          desc: '''
            Pad signal configuration.
          '''
          swaccess: "rw"
          fields: [
            {
                bits: "0"
                name: chip2pad
                desc: '''
                     The signal that connects to the pads TX driver
                '''
                swaccess: "rw"
                hwaccess: "hro"
                resval: "0"
            },
            {
                bits: "1"
                name: oen
                desc: '''
                     Output enable signal, active low
                '''
                swaccess: "rw"
                hwaccess: "hro"
                resval: "1"
            },
          ]
      }

       {
          name: PAD_PWM2_MUX_SEL
          desc: '''
              Pad signal port multiplex selection for pad pad_pwm2. The programmed value defines which port
              is connected to the pad.
          '''
          swaccess: "rw"
          hwaccess: "hro"
          resval: 0
          fields: [
              {
                  bits: "3:0"
                  enum: [
                      { value: "0", name: "register", desc: "Connects the Pad to the internal configuration register."}
                      { value: "1", name: "port_pwm_pwm0", desc: "Connect port pwm0 from port group pwm to this pad." }
                      { value: "2", name: "port_pwm_pwm1", desc: "Connect port pwm1 from port group pwm to this pad." }
                      { value: "3", name: "port_pwm_pwm2", desc: "Connect port pwm2 from port group pwm to this pad." }
                      { value: "4", name: "port_pwm_pwm3", desc: "Connect port pwm3 from port group pwm to this pad." }
                      { value: "5", name: "port_pwm_pwm4", desc: "Connect port pwm4 from port group pwm to this pad." }
                      { value: "6", name: "port_pwm_pwm5", desc: "Connect port pwm5 from port group pwm to this pad." }
                      { value: "7", name: "port_pwm_pwm6", desc: "Connect port pwm6 from port group pwm to this pad." }
                      { value: "8", name: "port_pwm_pwm7", desc: "Connect port pwm7 from port group pwm to this pad." }
                  ]
              }
          ]
      }

      {
          name: PAD_PWM3_CFG
          desc: '''
            Pad signal configuration.
          '''
          swaccess: "rw"
          fields: [
            {
                bits: "0"
                name: chip2pad
                desc: '''
                     The signal that connects to the pads TX driver
                '''
                swaccess: "rw"
                hwaccess: "hro"
                resval: "0"
            },
            {
                bits: "1"
                name: oen
                desc: '''
                     Output enable signal, active low
                '''
                swaccess: "rw"
                hwaccess: "hro"
                resval: "1"
            },
          ]
      }

       {
          name: PAD_PWM3_MUX_SEL
          desc: '''
              Pad signal port multiplex selection for pad pad_pwm3. The programmed value defines which port
              is connected to the pad.
          '''
          swaccess: "rw"
          hwaccess: "hro"
          resval: 0
          fields: [
              {
                  bits: "3:0"
                  enum: [
                      { value: "0", name: "register", desc: "Connects the Pad to the internal configuration register."}
                      { value: "1", name: "port_pwm_pwm0", desc: "Connect port pwm0 from port group pwm to this pad." }
                      { value: "2", name: "port_pwm_pwm1", desc: "Connect port pwm1 from port group pwm to this pad." }
                      { value: "3", name: "port_pwm_pwm2", desc: "Connect port pwm2 from port group pwm to this pad." }
                      { value: "4", name: "port_pwm_pwm3", desc: "Connect port pwm3 from port group pwm to this pad." }
                      { value: "5", name: "port_pwm_pwm4", desc: "Connect port pwm4 from port group pwm to this pad." }
                      { value: "6", name: "port_pwm_pwm5", desc: "Connect port pwm5 from port group pwm to this pad." }
                      { value: "7", name: "port_pwm_pwm6", desc: "Connect port pwm6 from port group pwm to this pad." }
                      { value: "8", name: "port_pwm_pwm7", desc: "Connect port pwm7 from port group pwm to this pad." }
                  ]
              }
          ]
      }

      {
          name: PAD_PWM4_CFG
          desc: '''
            Pad signal configuration.
          '''
          swaccess: "rw"
          fields: [
            {
                bits: "0"
                name: chip2pad
                desc: '''
                     The signal that connects to the pads TX driver
                '''
                swaccess: "rw"
                hwaccess: "hro"
                resval: "0"
            },
            {
                bits: "1"
                name: oen
                desc: '''
                     Output enable signal, active low
                '''
                swaccess: "rw"
                hwaccess: "hro"
                resval: "1"
            },
          ]
      }

       {
          name: PAD_PWM4_MUX_SEL
          desc: '''
              Pad signal port multiplex selection for pad pad_pwm4. The programmed value defines which port
              is connected to the pad.
          '''
          swaccess: "rw"
          hwaccess: "hro"
          resval: 0
          fields: [
              {
                  bits: "3:0"
                  enum: [
                      { value: "0", name: "register", desc: "Connects the Pad to the internal configuration register."}
                      { value: "1", name: "port_pwm_pwm0", desc: "Connect port pwm0 from port group pwm to this pad." }
                      { value: "2", name: "port_pwm_pwm1", desc: "Connect port pwm1 from port group pwm to this pad." }
                      { value: "3", name: "port_pwm_pwm2", desc: "Connect port pwm2 from port group pwm to this pad." }
                      { value: "4", name: "port_pwm_pwm3", desc: "Connect port pwm3 from port group pwm to this pad." }
                      { value: "5", name: "port_pwm_pwm4", desc: "Connect port pwm4 from port group pwm to this pad." }
                      { value: "6", name: "port_pwm_pwm5", desc: "Connect port pwm5 from port group pwm to this pad." }
                      { value: "7", name: "port_pwm_pwm6", desc: "Connect port pwm6 from port group pwm to this pad." }
                      { value: "8", name: "port_pwm_pwm7", desc: "Connect port pwm7 from port group pwm to this pad." }
                  ]
              }
          ]
      }

      {
          name: PAD_PWM5_CFG
          desc: '''
            Pad signal configuration.
          '''
          swaccess: "rw"
          fields: [
            {
                bits: "0"
                name: chip2pad
                desc: '''
                     The signal that connects to the pads TX driver
                '''
                swaccess: "rw"
                hwaccess: "hro"
                resval: "0"
            },
            {
                bits: "1"
                name: oen
                desc: '''
                     Output enable signal, active low
                '''
                swaccess: "rw"
                hwaccess: "hro"
                resval: "1"
            },
          ]
      }

       {
          name: PAD_PWM5_MUX_SEL
          desc: '''
              Pad signal port multiplex selection for pad pad_pwm5. The programmed value defines which port
              is connected to the pad.
          '''
          swaccess: "rw"
          hwaccess: "hro"
          resval: 0
          fields: [
              {
                  bits: "3:0"
                  enum: [
                      { value: "0", name: "register", desc: "Connects the Pad to the internal configuration register."}
                      { value: "1", name: "port_pwm_pwm0", desc: "Connect port pwm0 from port group pwm to this pad." }
                      { value: "2", name: "port_pwm_pwm1", desc: "Connect port pwm1 from port group pwm to this pad." }
                      { value: "3", name: "port_pwm_pwm2", desc: "Connect port pwm2 from port group pwm to this pad." }
                      { value: "4", name: "port_pwm_pwm3", desc: "Connect port pwm3 from port group pwm to this pad." }
                      { value: "5", name: "port_pwm_pwm4", desc: "Connect port pwm4 from port group pwm to this pad." }
                      { value: "6", name: "port_pwm_pwm5", desc: "Connect port pwm5 from port group pwm to this pad." }
                      { value: "7", name: "port_pwm_pwm6", desc: "Connect port pwm6 from port group pwm to this pad." }
                      { value: "8", name: "port_pwm_pwm7", desc: "Connect port pwm7 from port group pwm to this pad." }
                  ]
              }
          ]
      }

      {
          name: PAD_PWM6_CFG
          desc: '''
            Pad signal configuration.
          '''
          swaccess: "rw"
          fields: [
            {
                bits: "0"
                name: chip2pad
                desc: '''
                     The signal that connects to the pads TX driver
                '''
                swaccess: "rw"
                hwaccess: "hro"
                resval: "0"
            },
            {
                bits: "1"
                name: oen
                desc: '''
                     Output enable signal, active low
                '''
                swaccess: "rw"
                hwaccess: "hro"
                resval: "1"
            },
          ]
      }

       {
          name: PAD_PWM6_MUX_SEL
          desc: '''
              Pad signal port multiplex selection for pad pad_pwm6. The programmed value defines which port
              is connected to the pad.
          '''
          swaccess: "rw"
          hwaccess: "hro"
          resval: 0
          fields: [
              {
                  bits: "3:0"
                  enum: [
                      { value: "0", name: "register", desc: "Connects the Pad to the internal configuration register."}
                      { value: "1", name: "port_pwm_pwm0", desc: "Connect port pwm0 from port group pwm to this pad." }
                      { value: "2", name: "port_pwm_pwm1", desc: "Connect port pwm1 from port group pwm to this pad." }
                      { value: "3", name: "port_pwm_pwm2", desc: "Connect port pwm2 from port group pwm to this pad." }
                      { value: "4", name: "port_pwm_pwm3", desc: "Connect port pwm3 from port group pwm to this pad." }
                      { value: "5", name: "port_pwm_pwm4", desc: "Connect port pwm4 from port group pwm to this pad." }
                      { value: "6", name: "port_pwm_pwm5", desc: "Connect port pwm5 from port group pwm to this pad." }
                      { value: "7", name: "port_pwm_pwm6", desc: "Connect port pwm6 from port group pwm to this pad." }
                      { value: "8", name: "port_pwm_pwm7", desc: "Connect port pwm7 from port group pwm to this pad." }
                  ]
              }
          ]
      }

      {
          name: PAD_PWM7_CFG
          desc: '''
            Pad signal configuration.
          '''
          swaccess: "rw"
          fields: [
            {
                bits: "0"
                name: chip2pad
                desc: '''
                     The signal that connects to the pads TX driver
                '''
                swaccess: "rw"
                hwaccess: "hro"
                resval: "0"
            },
            {
                bits: "1"
                name: oen
                desc: '''
                     Output enable signal, active low
                '''
                swaccess: "rw"
                hwaccess: "hro"
                resval: "1"
            },
          ]
      }

       {
          name: PAD_PWM7_MUX_SEL
          desc: '''
              Pad signal port multiplex selection for pad pad_pwm7. The programmed value defines which port
              is connected to the pad.
          '''
          swaccess: "rw"
          hwaccess: "hro"
          resval: 0
          fields: [
              {
                  bits: "3:0"
                  enum: [
                      { value: "0", name: "register", desc: "Connects the Pad to the internal configuration register."}
                      { value: "1", name: "port_pwm_pwm0", desc: "Connect port pwm0 from port group pwm to this pad." }
                      { value: "2", name: "port_pwm_pwm1", desc: "Connect port pwm1 from port group pwm to this pad." }
                      { value: "3", name: "port_pwm_pwm2", desc: "Connect port pwm2 from port group pwm to this pad." }
                      { value: "4", name: "port_pwm_pwm3", desc: "Connect port pwm3 from port group pwm to this pad." }
                      { value: "5", name: "port_pwm_pwm4", desc: "Connect port pwm4 from port group pwm to this pad." }
                      { value: "6", name: "port_pwm_pwm5", desc: "Connect port pwm5 from port group pwm to this pad." }
                      { value: "7", name: "port_pwm_pwm6", desc: "Connect port pwm6 from port group pwm to this pad." }
                      { value: "8", name: "port_pwm_pwm7", desc: "Connect port pwm7 from port group pwm to this pad." }
                  ]
              }
          ]
      }

    ]
}
